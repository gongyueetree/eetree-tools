* opint-slew
* Converted from CircuitJS by eetree.cn/tools - open in LTspice (File > Open, then Run)
* Suggested traces: V(N024) V(N018)
Q1 N001 0 N002 QNPN_100
Q2 N004 N003 N002 QPNP_100
Q3 N005 N004 N006 QNPN_100
Q4 N004 N006 N007 QNPN_100
R1 N007 N008 1k
R2 N006 N008 50k
Q5 N001 N009 N010 QNPN_100
Q6 N011 N003 N010 QPNP_100
Q7 N011 N006 N012 QNPN_100
R3 N012 N008 1k
V1 N008 0 -15
Q8 N001 N001 N005 QPNP_100
Q9 N003 N001 N005 QPNP_100
V2 N005 0 15
Q10 N003 N013 N014 QNPN_100
Q11 N013 N013 N008 QNPN_100
R4 N014 N008 5k
R5 N013 N015 39k
Q12 N015 N015 N005 QPNP_100
Q13 N016 N015 N005 QPNP_100
Q14 N005 N016 N017 QNPN_100
Q15 N016 N017 N018 QNPN_100
R6 N017 N018 25
R7 N018 N019 50
Q16 N016 N020 N021 QNPN_100
R8 N020 N016 4.5k
R9 N020 N021 7.5k
Q17 N008 N021 N019 QPNP_100
Q18 N021 N022 N023 QNPN_100
Q19 N011 N023 N008 QNPN_100
R10 N023 N008 50
R11 N022 N008 50k
Q20 N021 N011 N022 QNPN_100
C1 N016 N011 30p IC=22.41581923
R12 N009 N018 2k
R13 N009 N024 1k
V3 N024 0 PULSE(-5 5 0 8.333333333n 8.333333333n 41.66666667u 83.33333333u)
.model QNPN_100 NPN(BF=100 BR=1 IS=1e-13 Cje=1p Cjc=1p)
.model QPNP_100 PNP(BF=100 BR=1 IS=1e-13 Cje=1p Cjc=1p)
.tran 200n 1.92m 0 200n uic
.end
