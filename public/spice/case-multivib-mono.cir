* multivib-mono
* Converted from CircuitJS by eetree.cn/tools - open in LTspice (File > Open, then Run)
* Suggested traces: V(N003,N004)
R1 N001 N002 330
R2 N001 N003 1.02k
R3 N001 N004 320
C1 N002 N003 18u IC=4.344956645
Q1 N004 N003 0 QNPN_100
Q2 N002 N005 0 QNPN_100
R4 N005 N004 100
Q3 N002 N006 0 QNPN_100
R5 N001 N007 100
* switch open
R6 N007 N006 1e12
V1 N001 0 5
.model QNPN_100 NPN(BF=100 BR=1 IS=1e-13 Cje=1p Cjc=1p)
.tran 5u 768m 0 5u uic
.end
