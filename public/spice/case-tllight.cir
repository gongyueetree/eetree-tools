* tllight
* Converted from CircuitJS by eetree.cn/tools - open in LTspice (File > Open, then Run)
* Suggested traces: V(N001,N004) V(N005)
T1 N002 N001 N003 0 Z0=300 Td=60n
R1 N002 N004 10
R2 N005 0 70
V1 N004 N001 SIN(0 169.7056275 60 0 0 90)
T2 N006 0 N005 0 Z0=300 Td=10n
* switch closed
R3 N003 N006 1m
* floating sub-circuit: reference to ground as in CircuitJS
R4 N002 0 100meg
.tran 307.2p 6.144u 0 307.2p uic
.end
