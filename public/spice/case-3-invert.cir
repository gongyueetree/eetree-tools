* 3-invert
* Converted from CircuitJS by eetree.cn/tools - open in LTspice (File > Open, then Run)
M1 N002 N001 0 0 MN_3p25_20m
M2 N003 N001 N002 N002 MN_m1p75_20m
M3 N003 N001 N004 N004 MP_m1p75_20m
V1 N004 0 2.5
M4 N002 N001 N005 N005 MP_3p25_20m
V2 N005 0 5
* logic input H
V3 N001 0 5
.model MN_3p25_20m NMOS(Level=1 VTO=3.25 KP=20m)
.model MN_m1p75_20m NMOS(Level=1 VTO=-1.75 KP=20m)
.model MP_3p25_20m PMOS(Level=1 VTO=-3.25 KP=20m)
.model MP_m1p75_20m PMOS(Level=1 VTO=1.75 KP=20m)
.tran 5u 768m 0 5u uic
.end
