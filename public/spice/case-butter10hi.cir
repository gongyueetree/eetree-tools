* butter10hi
* Converted from CircuitJS by eetree.cn/tools - open in LTspice (File > Open, then Run)
* Suggested traces: V(N001)
R1 N001 0 50
V1 N002 0 DC 0 AC 5
C1 N002 N003 1.020027325u IC=1.418500015
L1 N003 0 2.150316434m IC=33.2743085m
C2 N003 N004 880.5602786n IC=-116.0765141m
L2 N004 0 2.364814374m IC=-2.554336952m
C3 N004 N005 1.05673966u IC=7.995853455m
L3 N005 0 3.087383986m IC=314.4496253u
C4 N005 N006 1.533388969u IC=1.419599616m
L4 N006 0 5.230847406m IC=-57.95890531u
C5 N006 N001 3.428761971u IC=-2.080734297m
L5 N001 0 25.50068314m IC=-12.81942931u
.ac dec 100 500 8k
.end
