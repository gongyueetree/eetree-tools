# eetree-sim 1
# name lc-lp-pi-3
# param RS 50
# param RL 50
# param fc 1000000
# param SCOPE_W 512
# param C1 3.1830988618379066e-09
# param L1 1.5915494309189534e-05
# param C2 3.1830988618379066e-09
# let fmin = fc/10
# let fmax = fc*4
# let dt = 1/(fmax*24)
# let tsw = 200/fmin
# let ssp = max(1, round(tsw/dt/SCOPE_W))
# let sp = 300
* lc-lp-pi-3
* Converted from CircuitJS by eetree.cn/tools - open in LTspice (File > Open, then Run)
* Suggested traces: V(OUT)
.param C1=${C1} C2=${C2} L1=${L1} RL=${RL} RS=${RS} fmax=${fmax} fmin=${fmin}
RS N001 N002 {RS}
C1 N002 0 {C1} IC=0
L1 N002 OUT {L1} IC=0
C2 OUT 0 {C2} IC=0
RL OUT 0 {RL}
V1 N001 0 DC 0 AC 2
.ac dec 100 {fmin} {fmax}
.end
