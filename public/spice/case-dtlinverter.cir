* dtlinverter
* Converted from CircuitJS by eetree.cn/tools - open in LTspice (File > Open, then Run)
R1 N001 N002 4.7k
R2 N002 N003 1k
Q1 N003 N004 0 QNPN_100
D1 N001 N004 D_VF0p8059
D2 N001 N005 D_VF0p8059
* logic input H
V1 N005 0 5
V2 N002 0 5
.model D_VF0p8059 D(Is=1.71435e-07 N=2 Rs=0.001 Cjo=1p)
.model QNPN_100 NPN(BF=100 BR=1 IS=1e-13 Cje=1p Cjc=1p)
.tran 5u 768m 0 5u uic
.end
