* moscurrentsrc
* Converted from CircuitJS by eetree.cn/tools - open in LTspice (File > Open, then Run)
M1 N002 N001 0 0 MN_1p5_20m
V1 N003 0 10
R1 N003 N002 300
* switch open
R2 N003 N002 1e12
V2 N001 0 3
.model MN_1p5_20m NMOS(Level=1 VTO=1.5 KP=20m)
.tran 5u 768m 0 5u uic
.end
