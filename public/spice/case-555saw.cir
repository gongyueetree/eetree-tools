* 555saw
* Converted from CircuitJS by eetree.cn/tools - open in LTspice (File > Open, then Run)
* Suggested traces: V(N004)
R1 N001 N002 39k
R2 N003 N002 27k
R3 N003 0 120k
V1 N002 0 15
C1 N004 0 200n IC=1m
R4 N004 N005 10k
Q1 N004 N003 N001 QPNP_100
* 555 timer 1 (CircuitJS TimerElm behaviour)
R_555a1 N002 N006 5k
R_555b1 N006 0 10k
B_555q1 Q555_1x 0 V=(u(V(N006,0)/2-V(N004,0))+(1-u(V(N006,0)/2-V(N004,0)))*(1-u(V(N004)-V(N006)))*u(V(Q555_1)-0.5))*u(V(N002,0)-0.7)
R_555q1 Q555_1x Q555_1 1k
C_555q1 Q555_1 0 1p
B_555o1 Q555_1o 0 V=V(0)+V(Q555_1)*V(N002,0)
R_555o1 Q555_1o N007 1
B_555d1 N005 0 I=(1-V(Q555_1))*V(N005,0)/10
.model QPNP_100 PNP(BF=100 BR=1 IS=1e-13 Cje=1p Cjc=1p)
.tran 5u 768m 0 5u uic
.end
