* diodecurve
* Converted from CircuitJS by eetree.cn/tools - open in LTspice (File > Open, then Run)
* Suggested traces: V(N001)
V1 N001 0 PULSE(-400m 900m 0 10m 10m 0 20m)
D1 N001 0 D_VF0p8059
.model D_VF0p8059 D(Is=1.71435e-07 N=2 Rs=0.001 Cjo=1p)
.tran 5u 768m 0 5u uic
.end
