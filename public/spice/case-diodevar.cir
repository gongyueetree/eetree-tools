* diodevar
* Converted from CircuitJS by eetree.cn/tools - open in LTspice (File > Open, then Run)
V1 N001 0 720m
D1 N001 0 D_VF0p8059
.model D_VF0p8059 D(Is=1.71435e-07 N=2 Rs=0.001 Cjo=1p)
.tran 5u 768m 0 5u uic
.end
