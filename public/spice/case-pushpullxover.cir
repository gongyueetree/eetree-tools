* pushpullxover
* Converted from CircuitJS by eetree.cn/tools - open in LTspice (File > Open, then Run)
* Suggested traces: V(N001) V(N003)
Q1 N002 N001 N003 QNPN_100
Q2 N004 N001 N003 QPNP_100
V1 N001 0 SIN(0 5 40 0 0 0)
V2 N002 0 10
V3 N004 0 -10
R1 N003 0 10
.model QNPN_100 NPN(BF=100 BR=1 IS=1e-13 Cje=1p Cjc=1p)
.model QPNP_100 PNP(BF=100 BR=1 IS=1e-13 Cje=1p Cjc=1p)
.tran 5u 768m 0 5u uic
.end
