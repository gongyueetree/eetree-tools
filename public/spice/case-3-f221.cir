* 3-f221
* Converted from CircuitJS by eetree.cn/tools - open in LTspice (File > Open, then Run)
M1 N003 N001 N002 N002 MN_750m_20m
M2 N003 N001 N004 N004 MP_750m_20m
V1 N004 0 5
* logic input L
V2 N001 0 0
V3 N002 0 2.5
.model MN_750m_20m NMOS(Level=1 VTO=750m KP=20m)
.model MP_750m_20m PMOS(Level=1 VTO=-750m KP=20m)
.tran 5u 768m 0 5u uic
.end
