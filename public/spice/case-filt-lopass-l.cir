* filt-lopass-l
* Converted from CircuitJS by eetree.cn/tools - open in LTspice (File > Open, then Run)
* Suggested traces: V(N002) V(N001)
R1 N001 0 35
L1 N002 N001 65.45m IC=0
V1 N002 0 DC 0 AC 5
.ac dec 100 20 1k
.end
