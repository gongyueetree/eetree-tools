* diodelimit
* Converted from CircuitJS by eetree.cn/tools - open in LTspice (File > Open, then Run)
* Suggested traces: V(N001) V(N002)
V1 N001 0 SIN(0 5 40 0 0 0)
R1 N001 N002 110
D1 N002 0 D_VF0p8059
D2 0 N002 D_VF0p8059
.model D_VF0p8059 D(Is=1.71435e-07 N=2 Rs=0.001 Cjo=1p)
.tran 5u 768m 0 5u uic
.end
