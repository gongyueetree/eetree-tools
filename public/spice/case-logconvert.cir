* logconvert
* Converted from CircuitJS by eetree.cn/tools - open in LTspice (File > Open, then Run)
* Suggested traces: V(N003) V(N007)
* op-amp 1: A0=100000, GBW=1000000, output limited to [-15.0, 15.0]
G_OA1 0 OA1 0 N001 1
R_OA1 OA1 0 100k
C_OA1 OA1 0 159.1549431n
B_OA1 N002 0 V=min(max(V(OA1), -15), 15)
D1 N002 N001 D_VF0p8059
C1 N001 N002 1u IC=655.5203584m
R1 N001 N003 1k
V1 N003 0 SIN(3 3 40 0 0 0)
Q1 N004 N004 N002 QNPN_100
I1 N005 N004 10m
V2 N005 0 10
* op-amp 2: A0=100000, GBW=1000000, output limited to [-15.0, 15.0]
G_OA2 0 OA2 N004 N006 1
R_OA2 OA2 0 100k
C_OA2 OA2 0 159.1549431n
B_OA2 N007 0 V=min(max(V(OA2), -15), 15)
R2 N006 N007 15k
R3 N006 0 1k
Q2 N001 0 N002 QNPN_100
.model D_VF0p8059 D(Is=1.71435e-07 N=2 Rs=0.001 Cjo=1p)
.model QNPN_100 NPN(BF=100 BR=1 IS=1e-13 Cje=1p Cjc=1p)
.tran 5u 768m 0 5u uic
.end
