* itov
* Converted from CircuitJS by eetree.cn/tools - open in LTspice (File > Open, then Run)
* Suggested traces: V(N001,N001) V(N002)
R1 N001 N002 1.001k
* SPDT switch throw 0 off
R2 N003 N004 1e12
* SPDT switch throw 1 on
R3 N003 N001 1m
* SPDT switch throw 0 off
R4 N005 N001 1e12
* SPDT switch throw 1 on
R5 N005 N004 1m
R6 N006 N004 1k
I1 N005 N006 1m
I2 N003 N006 2m
* op-amp 1: A0=100000, GBW=1000000, output limited to [-15, 15]
G_OA1 0 OA1 0 N001 1
R_OA1 OA1 0 100k
C_OA1 OA1 0 159.1549431n
B_OA1 N002 0 V=min(max(V(OA1), -15), 15)
V1 N006 0 -5
.tran 5u 768m 0 5u uic
.end
