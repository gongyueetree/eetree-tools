* cmosinverter
* Converted from CircuitJS by eetree.cn/tools - open in LTspice (File > Open, then Run)
M1 N002 N001 N003 N003 MP_1p5_20m
M2 N002 N001 0 0 MN_1p5_20m
* logic input H
V1 N001 0 5
V2 N003 0 5
.model MN_1p5_20m NMOS(Level=1 VTO=1.5 KP=20m)
.model MP_1p5_20m PMOS(Level=1 VTO=-1.5 KP=20m)
.tran 5u 768m 0 5u uic
.end
