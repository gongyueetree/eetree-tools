# eetree-sim 1
# name bjt-astable-led
# param RC 330
# param R1 47000
# param R2 47000
# param C1 1e-05
# param C2 1e-05
# param VCC 5
# param beta 100
# let T = 0.75*(R1*C1+R2*C2)
# let dt = T/1000
# let sp = 6
* bjt-astable-led
* Converted from CircuitJS by eetree.cn/tools - open in LTspice (File > Open, then Run)
* Suggested traces: V(OUT)
.param C1=${C1} C2=${C2} R1=${R1} R2=${R2} RC=${RC} VCC=${VCC}
RC vcc N001 {RC}
D1 N001 N002 D_VF2p102
R1 vcc N003 {RC}
D2 N003 OUT D_VF2p102
R2 vcc N004 {R2}
R3 vcc N005 {R1}
C2 N002 N004 {C2} IC=0
C1 N005 OUT {C1} IC=500m
VCC vcc 0 {VCC}
Q1 N002 N005 0 QNPN_100
Q2 OUT N004 0 QNPN_100
.model D_VF2p102 D(Is=2.23499e-18 N=2 Rs=0.001 Cjo=1p)
.model QNPN_100 NPN(BF=100 BR=1 IS=1e-13 Cje=1p Cjc=1p)
.tran ${max((dt),(dt)*19200/200000)} ${(dt)*19200} 0 ${max((dt),(dt)*19200/200000)} uic
.end
