* ttlnand
* Converted from CircuitJS by eetree.cn/tools - open in LTspice (File > Open, then Run)
V1 N001 0 5
R1 N001 N002 1k
Q1 N004 N003 N005 QNPN_100
Q2 N004 N003 N006 QNPN_100
Q3 N002 N004 0 QNPN_100
* logic input H
V2 N005 0 5
* logic input L
V3 N006 0 0
R2 N001 N003 4.7k
.model QNPN_100 NPN(BF=100 BR=1 IS=1e-13 Cje=1p Cjc=1p)
.tran 5u 768m 0 5u uic
.end
