* rtlinverter
* Converted from CircuitJS by eetree.cn/tools - open in LTspice (File > Open, then Run)
R1 N001 N002 470
Q1 N003 N002 0 QNPN_100
R2 N003 N004 640
* logic input H
V1 N001 0 3.6
V2 N004 0 3.6
.model QNPN_100 NPN(BF=100 BR=1 IS=1e-13 Cje=1p Cjc=1p)
.tran 5u 768m 0 5u uic
.end
