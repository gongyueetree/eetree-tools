* nmosnand
* Converted from CircuitJS by eetree.cn/tools - open in LTspice (File > Open, then Run)
M1 N003 N001 N002 N002 MN_1p5_20m
M2 N002 N004 0 0 MN_1p5_20m
V1 N005 0 5
* logic input H
V2 N001 0 5
* logic input H
V3 N004 0 5
R1 N005 N003 5k
.model MN_1p5_20m NMOS(Level=1 VTO=1.5 KP=20m)
.tran 5u 768m 0 5u uic
.end
