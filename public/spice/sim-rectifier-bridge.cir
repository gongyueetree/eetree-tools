# eetree-sim 1
# name rectifier-bridge
# param VP 16.97
# param f 50
# param C1 0.0022
# param RL 30
# let dt = 1/(f*400)
# let sp = 2.5
* rectifier-bridge
* Converted from CircuitJS by eetree.cn/tools - open in LTspice (File > Open, then Run)
* Suggested traces: V(N001,N002) V(N002,VOUT)
.param C1=${C1} RL=${RL} VP=${VP} f=${f}
V1 N002 N001 SIN(0 {VP} {f} 0 0 0)
D1 N002 VOUT D_VF0p8059
D2 0 N002 D_VF0p8059
D3 N001 VOUT D_VF0p8059
D4 0 N001 D_VF0p8059
C1 VOUT 0 {C1} IC=0
RL VOUT 0 {RL}
.model D_VF0p8059 D(Is=1.71435e-07 N=2 Rs=0.001 Cjo=1p)
.tran ${max((dt),(dt)*4800/200000)} ${(dt)*4800} 0 ${max((dt),(dt)*4800/200000)} uic
.end
