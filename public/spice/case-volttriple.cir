* volttriple
* Converted from CircuitJS by eetree.cn/tools - open in LTspice (File > Open, then Run)
* Suggested traces: V(N001) V(N004)
D1 N001 N002 D_VF0p8059
D2 N002 N003 D_VF0p8059
C1 N001 N003 100u IC=0
C2 N002 0 100u IC=0
D3 N003 N004 D_VF0p8059
C3 N004 0 100u IC=0
R1 N004 0 40k
V1 N001 0 SIN(0 15 120 0 0 0)
.model D_VF0p8059 D(Is=1.71435e-07 N=2 Rs=0.001 Cjo=1p)
.tran 5u 768m 0 5u uic
.end
