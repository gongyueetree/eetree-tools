* resistors
* Converted from CircuitJS by eetree.cn/tools - open in LTspice (File > Open, then Run)
V1 N001 0 5
* switch closed
R1 N001 N002 1m
* switch open
R2 N001 N003 1e12
* switch closed
R3 N001 N004 1m
R4 N002 N005 100
R5 N003 N005 400
R6 N004 N005 800
* switch closed
R7 N005 N006 1m
* switch open
R8 N005 N007 1e12
R9 N007 0 600
R10 N006 0 200
* switch open
R11 N005 0 1e12
.tran 5u 768m 0 5u uic
.end
