* flashadc
* Converted from CircuitJS by eetree.cn/tools - open in LTspice (File > Open, then Run)
* Suggested traces: V(N002) V(N009) V(N018) V(N017)
* op-amp 1: A0=100000, GBW=1000000, output limited to [0.0, 5.0]
G_OA1 0 OA1 N002 N001 1
R_OA1 OA1 0 100k
C_OA1 OA1 0 159.1549431n
B_OA1 N003 0 V=min(max(V(OA1), 0), 5)
* op-amp 2: A0=100000, GBW=1000000, output limited to [0.0, 5.0]
G_OA2 0 OA2 N002 N004 1
R_OA2 OA2 0 100k
C_OA2 OA2 0 159.1549431n
B_OA2 N005 0 V=min(max(V(OA2), 0), 5)
* op-amp 3: A0=100000, GBW=1000000, output limited to [0.0, 5.0]
G_OA3 0 OA3 N002 N006 1
R_OA3 OA3 0 100k
C_OA3 OA3 0 159.1549431n
B_OA3 N007 0 V=min(max(V(OA3), 0), 5)
* op-amp 4: A0=100000, GBW=1000000, output limited to [0.0, 5.0]
G_OA4 0 OA4 N002 N008 1
R_OA4 OA4 0 100k
C_OA4 OA4 0 159.1549431n
B_OA4 N009 0 V=min(max(V(OA4), 0), 5)
* op-amp 5: A0=100000, GBW=1000000, output limited to [0.0, 5.0]
G_OA5 0 OA5 N002 N010 1
R_OA5 OA5 0 100k
C_OA5 OA5 0 159.1549431n
B_OA5 N011 0 V=min(max(V(OA5), 0), 5)
* op-amp 6: A0=100000, GBW=1000000, output limited to [0.0, 5.0]
G_OA6 0 OA6 N002 N012 1
R_OA6 OA6 0 100k
C_OA6 OA6 0 159.1549431n
B_OA6 N013 0 V=min(max(V(OA6), 0), 5)
* op-amp 7: A0=100000, GBW=1000000, output limited to [0.0, 5.0]
G_OA7 0 OA7 N002 N014 1
R_OA7 OA7 0 100k
C_OA7 OA7 0 159.1549431n
B_OA7 N015 0 V=min(max(V(OA7), 0), 5)
R1 N016 N001 500
R2 N001 N004 1k
R3 N004 N006 1k
R4 N006 N008 1k
R5 N008 N010 1k
R6 N010 N012 1k
R7 N012 N014 1k
R8 N014 0 500
V1 N016 0 7
V2 N002 0 PULSE(0 7 0 19.998m 2u 0 20m)
* logic gate (output 5 V, threshold 2.5 V, ~1 ns delay)
B1 B1x 0 V=5*(((((((u(V(N015)-2.5)+u(V(N013)-2.5)-2*u(V(N015)-2.5)*u(V(N013)-2.5))+u(V(N011)-2.5)-2*(u(V(N015)-2.5)+u(V(N013)-2.5)-2*u(V(N015)-2.5)*u(V(N013)-2.5))*u(V(N011)-2.5))+u(V(N009)-2.5)-2*((u(V(N015)-2.5)+u(V(N013)-2.5)-2*u(V(N015)-2.5)*u(V(N013)-2.5))+u(V(N011)-2.5)-2*(u(V(N015)-2.5)+u(V(N013)-2.5)-2*u(V(N015)-2.5)*u(V(N013)-2.5))*u(V(N011)-2.5))*u(V(N009)-2.5))+u(V(N007)-2.5)-2*(((u(V(N015)-2.5)+u(V(N013)-2.5)-2*u(V(N015)-2.5)*u(V(N013)-2.5))+u(V(N011)-2.5)-2*(u(V(N015)-2.5)+u(V(N013)-2.5)-2*u(V(N015)-2.5)*u(V(N013)-2.5))*u(V(N011)-2.5))+u(V(N009)-2.5)-2*((u(V(N015)-2.5)+u(V(N013)-2.5)-2*u(V(N015)-2.5)*u(V(N013)-2.5))+u(V(N011)-2.5)-2*(u(V(N015)-2.5)+u(V(N013)-2.5)-2*u(V(N015)-2.5)*u(V(N013)-2.5))*u(V(N011)-2.5))*u(V(N009)-2.5))*u(V(N007)-2.5))+u(V(N005)-2.5)-2*((((u(V(N015)-2.5)+u(V(N013)-2.5)-2*u(V(N015)-2.5)*u(V(N013)-2.5))+u(V(N011)-2.5)-2*(u(V(N015)-2.5)+u(V(N013)-2.5)-2*u(V(N015)-2.5)*u(V(N013)-2.5))*u(V(N011)-2.5))+u(V(N009)-2.5)-2*((u(V(N015)-2.5)+u(V(N013)-2.5)-2*u(V(N015)-2.5)*u(V(N013)-2.5))+u(V(N011)-2.5)-2*(u(V(N015)-2.5)+u(V(N013)-2.5)-2*u(V(N015)-2.5)*u(V(N013)-2.5))*u(V(N011)-2.5))*u(V(N009)-2.5))+u(V(N007)-2.5)-2*(((u(V(N015)-2.5)+u(V(N013)-2.5)-2*u(V(N015)-2.5)*u(V(N013)-2.5))+u(V(N011)-2.5)-2*(u(V(N015)-2.5)+u(V(N013)-2.5)-2*u(V(N015)-2.5)*u(V(N013)-2.5))*u(V(N011)-2.5))+u(V(N009)-2.5)-2*((u(V(N015)-2.5)+u(V(N013)-2.5)-2*u(V(N015)-2.5)*u(V(N013)-2.5))+u(V(N011)-2.5)-2*(u(V(N015)-2.5)+u(V(N013)-2.5)-2*u(V(N015)-2.5)*u(V(N013)-2.5))*u(V(N011)-2.5))*u(V(N009)-2.5))*u(V(N007)-2.5))*u(V(N005)-2.5))+u(V(N003)-2.5)-2*(((((u(V(N015)-2.5)+u(V(N013)-2.5)-2*u(V(N015)-2.5)*u(V(N013)-2.5))+u(V(N011)-2.5)-2*(u(V(N015)-2.5)+u(V(N013)-2.5)-2*u(V(N015)-2.5)*u(V(N013)-2.5))*u(V(N011)-2.5))+u(V(N009)-2.5)-2*((u(V(N015)-2.5)+u(V(N013)-2.5)-2*u(V(N015)-2.5)*u(V(N013)-2.5))+u(V(N011)-2.5)-2*(u(V(N015)-2.5)+u(V(N013)-2.5)-2*u(V(N015)-2.5)*u(V(N013)-2.5))*u(V(N011)-2.5))*u(V(N009)-2.5))+u(V(N007)-2.5)-2*(((u(V(N015)-2.5)+u(V(N013)-2.5)-2*u(V(N015)-2.5)*u(V(N013)-2.5))+u(V(N011)-2.5)-2*(u(V(N015)-2.5)+u(V(N013)-2.5)-2*u(V(N015)-2.5)*u(V(N013)-2.5))*u(V(N011)-2.5))+u(V(N009)-2.5)-2*((u(V(N015)-2.5)+u(V(N013)-2.5)-2*u(V(N015)-2.5)*u(V(N013)-2.5))+u(V(N011)-2.5)-2*(u(V(N015)-2.5)+u(V(N013)-2.5)-2*u(V(N015)-2.5)*u(V(N013)-2.5))*u(V(N011)-2.5))*u(V(N009)-2.5))*u(V(N007)-2.5))+u(V(N005)-2.5)-2*((((u(V(N015)-2.5)+u(V(N013)-2.5)-2*u(V(N015)-2.5)*u(V(N013)-2.5))+u(V(N011)-2.5)-2*(u(V(N015)-2.5)+u(V(N013)-2.5)-2*u(V(N015)-2.5)*u(V(N013)-2.5))*u(V(N011)-2.5))+u(V(N009)-2.5)-2*((u(V(N015)-2.5)+u(V(N013)-2.5)-2*u(V(N015)-2.5)*u(V(N013)-2.5))+u(V(N011)-2.5)-2*(u(V(N015)-2.5)+u(V(N013)-2.5)-2*u(V(N015)-2.5)*u(V(N013)-2.5))*u(V(N011)-2.5))*u(V(N009)-2.5))+u(V(N007)-2.5)-2*(((u(V(N015)-2.5)+u(V(N013)-2.5)-2*u(V(N015)-2.5)*u(V(N013)-2.5))+u(V(N011)-2.5)-2*(u(V(N015)-2.5)+u(V(N013)-2.5)-2*u(V(N015)-2.5)*u(V(N013)-2.5))*u(V(N011)-2.5))+u(V(N009)-2.5)-2*((u(V(N015)-2.5)+u(V(N013)-2.5)-2*u(V(N015)-2.5)*u(V(N013)-2.5))+u(V(N011)-2.5)-2*(u(V(N015)-2.5)+u(V(N013)-2.5)-2*u(V(N015)-2.5)*u(V(N013)-2.5))*u(V(N011)-2.5))*u(V(N009)-2.5))*u(V(N007)-2.5))*u(V(N005)-2.5))*u(V(N003)-2.5)))
RB1 B1x B1y 1k
CB1 B1y 0 1p IC=5
B1o N017 0 V=V(B1y)
* logic gate (output 5 V, threshold 2.5 V, ~1 ns delay)
B2 B2x 0 V=5*(((u(V(N013)-2.5)+u(V(N009)-2.5)-2*u(V(N013)-2.5)*u(V(N009)-2.5))+u(V(N005)-2.5)-2*(u(V(N013)-2.5)+u(V(N009)-2.5)-2*u(V(N013)-2.5)*u(V(N009)-2.5))*u(V(N005)-2.5)))
RB2 B2x B2y 1k
CB2 B2y 0 1p IC=5
B2o N018 0 V=V(B2y)
.tran 5u 384m 0 5u uic
.end
