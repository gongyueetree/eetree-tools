* clockedsrff
* Converted from CircuitJS by eetree.cn/tools - open in LTspice (File > Open, then Run)
* Suggested traces: V(N006) V(N007) V(N002) V(N005)
* logic gate (output 5 V, threshold 2.5 V, ~1 ns delay)
B1 B1x 0 V=5*(1-(u(V(N001)-2.5)*u(V(N002)-2.5)))
RB1 B1x B1y 1k
CB1 B1y 0 1p IC=5
B1o N003 0 V=V(B1y)
* logic gate (output 5 V, threshold 2.5 V, ~1 ns delay)
B2 B2x 0 V=5*(1-(u(V(N003)-2.5)*u(V(N004)-2.5)))
RB2 B2x B2y 1k
CB2 B2y 0 1p IC=0
B2o N002 0 V=V(B2y)
* logic gate (output 5 V, threshold 2.5 V, ~1 ns delay)
B3 B3x 0 V=5*(1-(u(V(N005)-2.5)*u(V(N006)-2.5)))
RB3 B3x B3y 1k
CB3 B3y 0 1p IC=5
B3o N004 0 V=V(B3y)
* logic gate (output 5 V, threshold 2.5 V, ~1 ns delay)
B4 B4x 0 V=5*(1-(u(V(N005)-2.5)*u(V(N007)-2.5)))
RB4 B4x B4y 1k
CB4 B4y 0 1p IC=0
B4o N001 0 V=V(B4y)
* logic input L
V1 N006 0 0
* logic input L
V2 N007 0 0
V3 N005 0 PULSE(0 5 0 1u 1u 5m 10m)
.tran 5u 768m 0 5u uic
.end
