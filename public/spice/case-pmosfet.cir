* pmosfet
* Converted from CircuitJS by eetree.cn/tools - open in LTspice (File > Open, then Run)
* Suggested traces: V(N001,N002)
V1 N001 0 2.5
M1 N002 N001 N003 N003 MP_1p5_20m
D1 N002 N003 D_body
V2 N002 0 3
V3 N003 0 5
.model D_body D(Is=1.7143528192808883e-7 N=2 Rs=1m Cjo=1p)
.model MP_1p5_20m PMOS(Level=1 VTO=-1.5 KP=20m)
.tran 5u 768m 0 5u uic
.end
