* switchfilter
* Converted from CircuitJS by eetree.cn/tools - open in LTspice (File > Open, then Run)
* Suggested traces: V(N006) V(N002)
M1 N002 N001 N003 N004 MP_1p5_20m
D1 N002 N003 D_body
M2 N003 N005 N002 0 MN_1p5_20m
D2 N002 N003 D_body
R1 N006 N003 50
R2 N006 N007 350
C1 N002 0 10u IC=2.665054141
* logic gate (output 5 V, threshold 2.5 V, ~1 ns delay)
B1 B1x 0 V=5*(1-u(V(N005)-2.5))
RB1 B1x B1y 1k
CB1 B1y 0 1p IC=0
B1o N001 0 V=V(B1y)
* logic input L
V1 N005 0 0
V2 N008 N006 SIN(0 1 500 0 0 0)
V3 N008 0 SIN(2.5 1 40 0 0 0)
M3 N007 N001 N002 0 MN_1p5_20m
D3 N002 N007 D_body
M4 N002 N005 N007 N004 MP_1p5_20m
D4 N002 N007 D_body
V4 N004 0 5
.model D_body D(Is=1.7143528192808883e-7 N=2 Rs=1m Cjo=1p)
.model MN_1p5_20m NMOS(Level=1 VTO=1.5 KP=20m)
.model MP_1p5_20m PMOS(Level=1 VTO=-1.5 KP=20m)
.tran 12u 921.6m 0 12u uic
.end
