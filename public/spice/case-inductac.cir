* inductac
* Converted from CircuitJS by eetree.cn/tools - open in LTspice (File > Open, then Run)
* Suggested traces: I(L1)
V1 N001 0 SIN(0 5 40 0 0 0)
R1 N001 N002 180
L1 N002 0 1 IC=-2.900944106m
.tran 5u 768m 0 5u uic
.end
