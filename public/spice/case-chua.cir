* chua
* Converted from CircuitJS by eetree.cn/tools - open in LTspice (File > Open, then Run)
* Suggested traces: V(N002) V(N006) V(N007)
* op-amp 1: A0=100000, GBW=1000000, output limited to [-15, 15]
G_OA1 0 OA1 N002 N001 1
R_OA1 OA1 0 100k
C_OA1 OA1 0 159.1549431n
B_OA1 N003 0 V=min(max(V(OA1), -15), 15)
* op-amp 2: A0=100000, GBW=1000000, output limited to [-15, 15]
G_OA2 0 OA2 N002 N004 1
R_OA2 OA2 0 100k
C_OA2 OA2 0 159.1549431n
B_OA2 N005 0 V=min(max(V(OA2), -15), 15)
R1 N002 N003 220
R2 N002 N005 22k
R3 N004 N005 22k
R4 N001 N003 220
R5 N004 0 3.3k
R6 0 N001 2.2k
C1 N002 0 10n IC=1.98745489
C2 N006 0 100n IC=-489.3413568m
R7 N006 N007 100
R8 N007 N008 1k
* op-amp 3: A0=100000, GBW=1000000, output limited to [-15, 15]
G_OA3 0 OA3 N006 N008 1
R_OA3 OA3 0 100k
C_OA3 OA3 0 159.1549431n
B_OA3 N009 0 V=min(max(V(OA3), -15), 15)
* op-amp 4: A0=100000, GBW=1000000, output limited to [-15, 15]
G_OA4 0 OA4 N010 N008 1
R_OA4 OA4 0 100k
C_OA4 OA4 0 159.1549431n
B_OA4 N007 0 V=min(max(V(OA4), -15), 15)
R9 N008 N009 1k
C3 N009 N010 100n IC=129.6345559m
* potentiometer
R10 N002 N006 1.547k
R11 N006 N006 953
* potentiometer
R12 N010 0 1.37375k
R13 0 0 1.12625k
.tran 5u 768m 0 5u uic
.end
