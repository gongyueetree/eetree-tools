# eetree-sim 1
# name lc-hp-pi-5
# param RS 50
# param RL 50
# param fc 1000000
# param SCOPE_W 512
# param L1 1.28759053700121e-05
# param C1 1.967263286166932e-09
# param L2 3.9788735772973834e-06
# param C2 1.967263286166932e-09
# param L3 1.2875905370012094e-05
# let fmin = fc/4
# let fmax = fc*10
# let dt = 1/(fmax*24)
# let tsw = 200/fmin
# let ssp = max(1, round(tsw/dt/SCOPE_W))
# let sp = 300
* lc-hp-pi-5
* Converted from CircuitJS by eetree.cn/tools - open in LTspice (File > Open, then Run)
* Suggested traces: V(OUT)
.param C1=${C1} C2=${C2} L1=${L1} L2=${L2} L3=${L3} RL=${RL} RS=${RS} fmax=${fmax} fmin=${fmin}
RS N001 N002 {RS}
L1 N002 0 {L1} IC=0
C1 N002 N003 {C1} IC=0
L2 N003 0 {L2} IC=0
C2 N003 OUT {C2} IC=0
L3 OUT 0 {L3} IC=0
RL OUT 0 {RL}
V1 N001 0 DC 0 AC 2
.ac dec 100 {fmin} {fmax}
.end
