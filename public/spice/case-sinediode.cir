* sinediode
* Converted from CircuitJS by eetree.cn/tools - open in LTspice (File > Open, then Run)
* Suggested traces: V(N020) V(N017)
D1 N001 N002 D_VF0p8059
D2 N002 N003 D_VF0p8059
R1 N003 N004 100
R2 N004 N001 100
R3 N003 N005 33
R4 N001 N006 33
D3 N006 N007 D_VF0p8059
D4 N007 N005 D_VF0p8059
D5 N008 N009 D_VF0p8059
D6 N009 N010 D_VF0p8059
R5 N006 N008 82
R6 N005 N010 82
R7 N008 N011 47
D7 N011 N012 D_VF0p8059
D8 N012 N013 D_VF0p8059
R8 N010 N013 47
R9 N011 N014 30
R10 N014 N015 39
D9 N014 N016 D_VF0p8059
D10 N015 N017 D_VF0p8059
D11 N016 N018 D_VF0p8059
D12 N017 N019 D_VF0p8059
R11 N013 N018 30
R12 N018 N019 39
V1 N019 0 2.4
V2 N015 0 -2.4
R13 N002 N017 2k
R14 N007 N017 1k
R15 N009 N017 470
R16 N012 N017 330
R17 N016 N017 120
R18 N017 N020 200
V3 N020 0 PULSE(-5 5 0 6.25m 6.25m 0 12.5m)
.model D_VF0p8059 D(Is=1.71435e-07 N=2 Rs=0.001 Cjo=1p)
.tran 5u 384m 0 5u uic
.end
