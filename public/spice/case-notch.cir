* notch
* Converted from CircuitJS by eetree.cn/tools - open in LTspice (File > Open, then Run)
* Suggested traces: V(N003) V(N001) I(L1) V(N002)
L1 N001 N002 500m IC=0
C1 N002 0 31.7u IC=0
R1 N003 N001 100
V1 N003 0 DC 0 AC 5
.ac dec 100 20 60
.end
