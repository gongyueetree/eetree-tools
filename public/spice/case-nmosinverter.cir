* nmosinverter
* Converted from CircuitJS by eetree.cn/tools - open in LTspice (File > Open, then Run)
V1 N001 0 5
* logic input H
V2 N002 0 5
R1 N001 N003 5k
M1 N003 N002 0 0 MN_1p5_20m
.model MN_1p5_20m NMOS(Level=1 VTO=1.5 KP=20m)
.tran 5u 768m 0 5u uic
.end
