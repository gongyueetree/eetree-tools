* amp-sum
* Converted from CircuitJS by eetree.cn/tools - open in LTspice (File > Open, then Run)
* Suggested traces: V(N003) V(N004) V(N002)
* op-amp 1: A0=100000, GBW=1000000, output limited to [-15.0, 15.0]
G_OA1 0 OA1 0 N001 1
R_OA1 OA1 0 100k
C_OA1 OA1 0 159.1549431n
B_OA1 N002 0 V=min(max(V(OA1), -15), 15)
R1 N001 N002 1k
R2 N001 N003 1k
R3 N004 N001 1k
V1 N003 0 SIN(0 5 200 0 0 0)
V2 N004 0 PULSE(-2 2 0 5u 5u 25m 50m)
.tran 5u 768m 0 5u uic
.end
