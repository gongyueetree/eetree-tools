* grid
* Converted from CircuitJS by eetree.cn/tools - open in LTspice (File > Open, then Run)
V1 N001 0 5
R1 N002 N003 5
R2 N003 N004 5
R3 N004 N005 5
R4 N005 N006 5
R5 N006 N007 5
R6 N007 N008 5
R7 N009 N010 5
R8 N010 N011 5
R9 N011 N012 5
R10 N012 N013 5
R11 N013 N014 5
R12 N014 N015 5
R13 N001 N016 5
R14 N016 N017 5
R15 N017 N018 5
R16 N018 N019 5
R17 N019 N020 5
R18 N020 0 5
R19 N021 N022 5
R20 N022 N023 5
R21 N023 N024 5
R22 N024 N025 5
R23 N025 N026 5
R24 N026 N027 5
R25 N028 N029 5
R26 N029 N030 5
R27 N030 N031 5
R28 N031 N032 5
R29 N032 N033 5
R30 N033 N034 5
R31 N002 N009 5
R32 N003 N010 5
R33 N004 N011 5
R34 N005 N012 5
R35 N006 N013 5
R36 N007 N014 5
R37 N008 N015 5
R38 N009 N001 5
R39 N010 N016 5
R40 N011 N017 5
R41 N012 N018 5
R42 N013 N019 5
R43 N014 N020 5
R44 N015 0 5
R45 N001 N021 5
R46 N016 N022 5
R47 N017 N023 5
R48 N018 N024 5
R49 N019 N025 5
R50 N020 N026 5
R51 0 N027 5
R52 N021 N028 5
R53 N022 N029 5
R54 N023 N030 5
R55 N024 N031 5
R56 N025 N032 5
R57 N026 N033 5
R58 N027 N034 5
.tran 5u 768m 0 5u uic
.end
