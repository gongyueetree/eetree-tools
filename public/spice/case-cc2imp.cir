* cc2imp
* Converted from CircuitJS by eetree.cn/tools - open in LTspice (File > Open, then Run)
* op-amp 1: A0=100000, GBW=1000000, output limited to [-15.0, 15.0]
G_OA1 0 OA1 N002 N001 1
R_OA1 OA1 0 100k
C_OA1 OA1 0 159.1549431n
B_OA1 N003 0 V=min(max(V(OA1), -15), 15)
M1 N004 N003 N001 N001 MN_1p5_20m
M2 N005 N003 N001 N001 MP_1p5_20m
M3 N005 N005 N006 N006 MN_1p5_20m
M4 N008 N005 N007 N007 MN_1p5_20m
M5 N004 N004 N009 N009 MP_1p5_20m
M6 N008 N004 N010 N010 MP_1p5_20m
V1 N002 0 2
* potentiometer
R1 N011 N012 353.95
R2 N012 N001 146.05
R3 N012 0 100
R4 N008 0 100
V2 N009 0 10
V3 N010 0 10
V4 N006 0 -10
V5 N007 0 -10
.model MN_1p5_20m NMOS(Level=1 VTO=1.5 KP=20m)
.model MP_1p5_20m PMOS(Level=1 VTO=-1.5 KP=20m)
.tran 5u 768m 0 5u uic
.end
