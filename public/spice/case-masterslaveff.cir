* masterslaveff
* Converted from CircuitJS by eetree.cn/tools - open in LTspice (File > Open, then Run)
* Suggested traces: V(N011) V(N003) V(N010)
* logic gate (output 5 V, threshold 2.5 V, ~1 ns delay)
B1 B1x 0 V=5*(1-(u(V(N001)-2.5)*u(V(N002)-2.5)))
RB1 B1x B1y 1k
CB1 B1y 0 1p IC=5
B1o N003 0 V=V(B1y)
* logic gate (output 5 V, threshold 2.5 V, ~1 ns delay)
B2 B2x 0 V=5*(1-(u(V(N004)-2.5)*u(V(N003)-2.5)))
RB2 B2x B2y 1k
CB2 B2y 0 1p IC=0
B2o N001 0 V=V(B2y)
* logic gate (output 5 V, threshold 2.5 V, ~1 ns delay)
B3 B3x 0 V=5*(1-(u(V(N005)-2.5)*u(V(N006)-2.5)))
RB3 B3x B3y 1k
CB3 B3y 0 1p IC=5
B3o N002 0 V=V(B3y)
* logic gate (output 5 V, threshold 2.5 V, ~1 ns delay)
B4 B4x 0 V=5*(1-(u(V(N007)-2.5)*u(V(N005)-2.5)))
RB4 B4x B4y 1k
CB4 B4y 0 1p IC=5
B4o N004 0 V=V(B4y)
* logic gate (output 5 V, threshold 2.5 V, ~1 ns delay)
B5 B5x 0 V=5*(1-(u(V(N007)-2.5)*u(V(N008)-2.5)))
RB5 B5x B5y 1k
CB5 B5y 0 1p IC=5
B5o N006 0 V=V(B5y)
* logic gate (output 5 V, threshold 2.5 V, ~1 ns delay)
B6 B6x 0 V=5*(1-(u(V(N009)-2.5)*u(V(N006)-2.5)))
RB6 B6x B6y 1k
CB6 B6y 0 1p IC=0
B6o N007 0 V=V(B6y)
* logic gate (output 5 V, threshold 2.5 V, ~1 ns delay)
B7 B7x 0 V=5*(1-(u(V(N010)-2.5)*u(V(N011)-2.5)))
RB7 B7x B7y 1k
CB7 B7y 0 1p IC=0
B7o N008 0 V=V(B7y)
* logic gate (output 5 V, threshold 2.5 V, ~1 ns delay)
B8 B8x 0 V=5*(1-(u(V(N010)-2.5)*u(V(N012)-2.5)))
RB8 B8x B8y 1k
CB8 B8y 0 1p IC=5
B8o N009 0 V=V(B8y)
* logic gate (output 5 V, threshold 2.5 V, ~1 ns delay)
B9 B9x 0 V=5*(1-u(V(N010)-2.5))
RB9 B9x B9y 1k
CB9 B9y 0 1p IC=0
B9o N005 0 V=V(B9y)
* logic gate (output 5 V, threshold 2.5 V, ~1 ns delay)
B10 B10x 0 V=5*(1-u(V(N011)-2.5))
RB10 B10x B10y 1k
CB10 B10y 0 1p IC=0
B10o N012 0 V=V(B10y)
* logic input H
V1 N011 0 5
V2 N010 0 PULSE(0 5 0 833.3333333n 833.3333333n 4.166666667m 8.333333333m)
.tran 5u 768m 0 5u uic
.end
