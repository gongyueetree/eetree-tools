* thevenin
* Converted from CircuitJS by eetree.cn/tools - open in LTspice (File > Open, then Run)
* Suggested traces: V(N013) V(N017)
R1 N001 N002 100
R2 N002 N003 100
R3 N003 N004 200
R4 N002 N005 100
R5 N006 N005 100
V1 N007 N005 5
V2 N008 N004 5
V3 N009 N001 5
V4 N010 N006 5
V5 N011 N003 5
R6 N011 N012 200
R7 N009 N013 400
R8 N007 0 100
R9 N008 N014 100
R10 N010 N015 1k
V6 N002 N015 5
V7 N011 N013 2
V8 N014 N012 5
R11 0 N014 100
R12 N004 N007 100
R13 N015 N001 100
R14 N016 N017 117.784267
V9 0 N016 2.80758
V10 0 N013 SIN(0 5 40 0 0 0)
V11 0 N017 SIN(0 5 40 0 0 0)
.tran 5u 768m 0 5u uic
.end
