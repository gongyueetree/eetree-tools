# eetree-sim 1
# name voltage-multiplier-full
# param VP 14.14
# param f 50
# param C 0.0001
# param RL 10000
# let dt = 1/(f*400)
# let sp = 40
* voltage-multiplier-full
* Converted from CircuitJS by eetree.cn/tools - open in LTspice (File > Open, then Run)
* Suggested traces: V(N001,N002) V(VOUT)
.param C=${C} RL=${RL} VP=${VP} f=${f}
V1 N002 N001 SIN(0 {VP} {f} 0 0 0)
D1 N002 VOUT D_VF0p8059
D2 0 N002 D_VF0p8059
C VOUT N001 {C} IC=0
C1 N001 0 {C} IC=0
RL VOUT 0 {RL}
.model D_VF0p8059 D(Is=1.71435e-07 N=2 Rs=0.001 Cjo=1p)
.tran ${max((dt),(dt)*153600/200000)} ${(dt)*153600} 0 ${max((dt),(dt)*153600/200000)} uic
.end
