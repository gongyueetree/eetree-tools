* 3-f220
* Converted from CircuitJS by eetree.cn/tools - open in LTspice (File > Open, then Run)
M1 N002 N001 0 0 MN_3p25_20m
M2 N002 N001 N003 N003 MP_750m_20m
V1 N003 0 5
* logic input L
V2 N001 0 0
.model MN_3p25_20m NMOS(Level=1 VTO=3.25 KP=20m)
.model MP_750m_20m PMOS(Level=1 VTO=-750m KP=20m)
.tran 5u 768m 0 5u uic
.end
