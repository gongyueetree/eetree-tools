# eetree-sim 1
# name snubber-rc
# param V 12
# param L1 0.1
# param Rcoil 400
# param Th 0.0015
# param dt 3.75e-06
# param Vg 10
# param SCOPE_W 512
# param Rs 1000
# param Cs 1e-07
# let sp = max(0.5, 2*Th/dt/800)
# let ssp = max(1, round(2*Th/dt/SCOPE_W))
* snubber-rc
* Converted from CircuitJS by eetree.cn/tools - open in LTspice (File > Open, then Run)
* Suggested traces: V(SW) I(L1)
.param Cs=${Cs} L1=${L1} Rcoil=${Rcoil} Rs=${Rs} V_=${V}
V v 0 {V_}
L1 v N001 {L1} IC=0
Rcoil N001 SW {Rcoil}
Rs v N002 {Rs}
Cs N002 SW {Cs} IC=0
V1 N003 0 PULSE(${(Vg/2)-(Vg/2)} ${(Vg/2)+(Vg/2)} 0 ${1/(1/(2*Th))*1e-4} ${1/(1/(2*Th))*1e-4} ${(0.5)/(1/(2*Th))} ${1/(1/(2*Th))})
M1 SW N003 0 0 MN_2_20m
.model MN_2_20m NMOS(Level=1 VTO=2 KP=20m)
.tran ${max((dt),(dt)*153600/200000)} ${(dt)*153600} 0 ${max((dt),(dt)*153600/200000)} uic
.end
