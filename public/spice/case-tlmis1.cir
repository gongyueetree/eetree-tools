* tlmis1
* Converted from CircuitJS by eetree.cn/tools - open in LTspice (File > Open, then Run)
* Suggested traces: V(N002,N004) V(N005)
T1 N002 N001 N003 0 Z0=75 Td=10n
R1 N002 N004 75
R2 N005 0 500
V1 N004 N001 SIN(0 5 187meg 0 0 0)
T2 N003 0 N005 0 Z0=500 Td=10n
* floating sub-circuit: reference to ground as in CircuitJS
R3 N002 0 100meg
.tran 38.4p 768n 0 38.4p uic
.end
