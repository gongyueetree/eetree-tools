* zenerreffollow
* Converted from CircuitJS by eetree.cn/tools - open in LTspice (File > Open, then Run)
* Suggested traces: V(N001) V(N004) V(N002)
V1 N001 0 SIN(8.8 2 40 0 0 0)
R1 N001 N002 10k
Q1 N003 N002 N004 QNPN_100
R2 N001 N003 100
D1 0 N002 D_VF0p8059_BV5p6
R3 N004 0 500
.model D_VF0p8059_BV5p6 D(Is=1.71435e-07 N=2 Rs=0.001 Cjo=1p BV=5.6 IBV=5m)
.model QNPN_100 NPN(BF=100 BR=1 IS=1e-13 Cje=1p Cjc=1p)
.tran 5u 768m 0 5u uic
.end
