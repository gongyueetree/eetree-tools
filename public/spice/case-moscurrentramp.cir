* moscurrentramp
* Converted from CircuitJS by eetree.cn/tools - open in LTspice (File > Open, then Run)
* Suggested traces: V(N003,N004)
R1 N001 0 10
V1 N002 0 2.5
V2 N003 0 10
C1 N003 N004 50u IC=0
R2 N003 N004 10k
* switch open
R3 N003 N004 1e12
M1 N004 N002 N001 N001 MN_1p5_20m
.model MN_1p5_20m NMOS(Level=1 VTO=1.5 KP=20m)
.tran 7.68u 1.536 0 7.68u uic
.end
