* capseries
* Converted from CircuitJS by eetree.cn/tools - open in LTspice (File > Open, then Run)
V1 N001 0 5
* SPDT switch throw 0 on
R1 N002 N001 1m
* SPDT switch throw 1 off
R2 N002 N003 1e12
R3 0 N004 100
R4 N004 N003 100
C1 N002 N005 1m IC=0
C2 N005 N004 100u IC=0
R5 N006 N007 100
R6 N007 N008 100
* SPDT switch throw 0 on
R7 N009 N010 1m
* SPDT switch throw 1 off
R8 N009 N008 1e12
C3 N009 N007 90.91u IC=0
V2 N010 N006 5
* floating sub-circuit: reference to ground as in CircuitJS
R9 N006 0 100meg
.tran 5u 768m 0 5u uic
.end
