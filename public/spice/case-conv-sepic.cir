* conv-sepic
* Converted from CircuitJS by eetree.cn/tools - open in LTspice (File > Open, then Run)
* Suggested traces: V(N005) V(N004) I(L2)
V1 N001 0 5
L1 N001 N002 1 IC=2.499203211m
C1 N002 N003 1u IC=3.296584211
L2 N003 0 10 IC=-4.464998086m
D1 N003 N004 D_default
M1 N002 N005 0 0 MN_1p5_20m
D2 0 N002 D_body
C2 N004 0 10u IC=4.172945864
R1 N004 0 1k
V2 N005 0 PULSE(0 10 0 100n 100n 500u 1m)
.model D_body D(Is=1.7143528192808883e-7 N=2 Rs=1m Cjo=1p)
.model D_default D(Is=1.71435e-07 N=2 Rs=0.001 Cjo=1p)
.model MN_1p5_20m NMOS(Level=1 VTO=1.5 KP=20m)
.tran 5u 48m 0 5u uic
.end
