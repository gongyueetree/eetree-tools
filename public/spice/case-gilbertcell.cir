* gilbertcell
* Converted from CircuitJS by eetree.cn/tools - open in LTspice (File > Open, then Run)
* Suggested traces: V(N001) V(N010) V(N020)
Q1 N002 N001 N003 QNPN_100
Q2 N004 0 N005 QNPN_100
R1 N003 N005 1k
Q3 N003 N006 N007 QNPN_100
Q4 N005 N006 N008 QNPN_100
R2 N007 N009 1k
R3 N008 N009 1k
V1 N009 0 -15
V2 N001 0 SIN(0 2 80 0 0 0)
V3 N010 0 PULSE(-2 2 0 50m 50m 0 100m)
Q5 N011 N010 N012 QNPN_100
Q6 N012 N006 N013 QNPN_100
R4 N012 N014 1k
Q7 N015 0 N014 QNPN_100
Q8 N014 N006 N016 QNPN_100
R5 N013 N009 1k
R6 N016 N009 1k
V4 N006 0 -12
Q9 N017 N002 N011 QNPN_100
Q10 N018 N004 N011 QNPN_100
Q11 N018 N002 N015 QNPN_100
Q12 N017 N004 N015 QNPN_100
Q13 N019 N019 N004 QNPN_100
Q14 N019 N019 N002 QNPN_100
R7 N019 0 1k
* op-amp 1: A0=100000, GBW=1000000, output limited to [-15, 15]
G_OA1 0 OA1 N017 N018 1
R_OA1 OA1 0 100k
C_OA1 OA1 0 159.1549431n
B_OA1 N020 0 V=min(max(V(OA1), -15), 15)
R8 N018 N020 4k
R9 N017 0 4k
R10 N018 N021 1k
R11 N017 N021 1k
D1 N019 N021 D_VF0p8059_BV5p6
V5 N021 0 15
.model D_VF0p8059_BV5p6 D(Is=1.71435e-07 N=2 Rs=0.001 Cjo=1p BV=5.6 IBV=5m)
.model QNPN_100 NPN(BF=100 BR=1 IS=1e-13 Cje=1p Cjc=1p)
.tran 5u 768m 0 5u uic
.end
