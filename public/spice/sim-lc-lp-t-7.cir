# eetree-sim 1
# name lc-lp-t-7
# param RS 50
# param RL 50
# param fc 1000000
# param SCOPE_W 512
# param L1 3.5415306580572623e-06
# param C1 3.969259357328153e-09
# param L2 1.433936488985789e-05
# param C2 6.366197723675814e-09
# param L3 1.433936488985789e-05
# param C3 3.969259357328157e-09
# param L4 3.5415306580572572e-06
# let fmin = fc/10
# let fmax = fc*4
# let dt = 1/(fmax*24)
# let tsw = 200/fmin
# let ssp = max(1, round(tsw/dt/SCOPE_W))
# let sp = 300
* lc-lp-t-7
* Converted from CircuitJS by eetree.cn/tools - open in LTspice (File > Open, then Run)
* Suggested traces: V(OUT)
.param C1=${C1} C2=${C2} C3=${C3} L1=${L1} L2=${L2} L3=${L3} L4=${L4} RL=${RL} RS=${RS} fmax=${fmax} fmin=${fmin}
RS N001 N002 {RS}
L1 N002 N003 {L1} IC=0
C1 N003 0 {C1} IC=0
L2 N003 N004 {L2} IC=0
C2 N004 0 {C2} IC=0
L3 N004 N005 {L3} IC=0
C3 N005 0 {C3} IC=0
L4 N005 OUT {L4} IC=0
RL OUT 0 {RL}
V1 N001 0 DC 0 AC 2
.ac dec 100 {fmin} {fmax}
.end
