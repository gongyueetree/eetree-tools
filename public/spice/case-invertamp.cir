* invertamp
* Converted from CircuitJS by eetree.cn/tools - open in LTspice (File > Open, then Run)
* Suggested traces: V(N004) V(N002)
M1 N002 N001 N003 N003 MP_1p5_20m
M2 N002 N001 0 0 MN_1p5_20m
V1 N003 0 5
C1 N001 N004 100n IC=2
V2 N004 0 SIN(0 10m 250 0 0 0)
R1 N002 N001 1meg
.model MN_1p5_20m NMOS(Level=1 VTO=1.5 KP=20m)
.model MP_1p5_20m PMOS(Level=1 VTO=-1.5 KP=20m)
.tran 5u 384m 0 5u uic
.end
