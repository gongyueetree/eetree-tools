* cube
* Converted from CircuitJS by eetree.cn/tools - open in LTspice (File > Open, then Run)
R1 N001 N002 100
R2 N002 N003 100
R3 N003 0 100
R4 0 N001 100
R5 N001 N004 100
R6 N002 N005 100
R7 N005 N004 100
R8 N005 N006 100
R9 N006 N003 100
R10 0 N007 100
R11 N007 N006 100
R12 N007 N004 100
V1 N005 0 5
.tran 5u 768m 0 5u uic
.end
