* jfetfollower
* Converted from CircuitJS by eetree.cn/tools - open in LTspice (File > Open, then Run)
* Suggested traces: V(N002) V(N001)
R1 N001 0 10k
J1 N003 N002 N001 JF_J1
V1 N002 0 SIN(0 2 40 0 0 0)
V2 N003 0 10
.model JF_J1 NJF(VTO=-4 BETA=625u)
.tran 5u 768m 0 5u uic
.end
