* darlington
* Converted from CircuitJS by eetree.cn/tools - open in LTspice (File > Open, then Run)
Q1 N002 N001 N003 QNPN_100
R1 N004 N005 2meg
* switch open
R2 N005 N001 1e12
R3 N004 N002 300
Q2 N002 N003 0 QNPN_100
V1 N004 0 5
.model QNPN_100 NPN(BF=100 BR=1 IS=1e-13 Cje=1p Cjc=1p)
.tran 5u 768m 0 5u uic
.end
