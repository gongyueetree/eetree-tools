* trans-diffamp-common
* Converted from CircuitJS by eetree.cn/tools - open in LTspice (File > Open, then Run)
* Suggested traces: V(N001) V(N004) V(N005)
Q1 N002 N001 N003 QNPN_100
Q2 N005 N004 N006 QNPN_100
R1 N003 N007 1k
R2 N007 N006 1k
R3 N007 N008 75k
R4 N005 N002 75k
V1 N002 0 15
V2 N008 0 -15
V3 N001 0 SIN(0 1 40 0 0 0)
V4 N004 0 SIN(0 1 40 0 0 0)
.model QNPN_100 NPN(BF=100 BR=1 IS=1e-13 Cje=1p Cjc=1p)
.tran 5u 384m 0 5u uic
.end
