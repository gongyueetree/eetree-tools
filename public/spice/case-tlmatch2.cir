* tlmatch2
* Converted from CircuitJS by eetree.cn/tools - open in LTspice (File > Open, then Run)
* Suggested traces: V(N004) V(N008)
T1 N001 0 N002 0 Z0=75 Td=10n
R1 N001 N003 75
R2 N004 0 300
V1 N003 0 SIN(0 5 100meg 0 0 0)
V2 0 N005 SIN(0 5 100meg 0 0 0)
R3 N005 N006 75
T2 N006 0 N007 0 Z0=75 Td=11.7621n
R4 N008 0 300
T3 N002 0 N009 0 Z0=75 Td=1.7621n
T4 N002 0 N010 0 Z0=75 Td=3.4358n
T5 N009 0 N004 0 Z0=300 Td=10n
T6 N007 0 N008 0 Z0=300 Td=10n
.tran 76.8p 1.536u 0 76.8p uic
.end
