* rmsconverter
* Converted from CircuitJS by eetree.cn/tools - open in LTspice (File > Open, then Run)
* Suggested traces: V(N019)
* op-amp 1: A0=100000, GBW=1000000, output limited to [-15, 15]
G_OA1 0 OA1 0 N001 1
R_OA1 OA1 0 100k
C_OA1 OA1 0 159.1549431n
B_OA1 N002 0 V=min(max(V(OA1), -15), 15)
* op-amp 2: A0=100000, GBW=1000000, output limited to [-15, 15]
G_OA2 0 OA2 0 N003 1
R_OA2 OA2 0 100k
C_OA2 OA2 0 159.1549431n
B_OA2 N004 0 V=min(max(V(OA2), -15), 15)
D1 N001 N002 D_VF0p8059
D2 N002 N005 D_VF0p8059
R1 N001 N005 100k
R2 N006 N001 100k
R3 N005 N003 50k
* op-amp 3: A0=100000, GBW=1000000, output limited to [-15, 15]
G_OA3 0 OA3 N008 N007 1
R_OA3 OA3 0 100k
C_OA3 OA3 0 159.1549431n
B_OA3 N009 0 V=min(max(V(OA3), -15), 15)
C1 N007 N009 30p IC=1m
R4 N007 N010 1k
R5 N010 N005 50k
R6 0 N008 1k
R7 N008 N011 100k
* potentiometer
R8 N012 N011 5k
R9 N011 N013 5k
V1 N012 0 1.2
V2 N013 0 -1.2
R10 N006 N003 100k
R11 N006 N010 100k
C2 N004 N003 15p IC=1m
D3 N004 N003 D_VF0p8059
Q1 N003 N009 N014 QNPN_100
R12 N014 N004 2k
Q2 N010 N010 N015 QNPN_100
Q3 N016 N009 N015 QNPN_100
D4 N010 N009 D_VF0p8059
R13 N015 N017 2k
C3 N017 N016 15p IC=1m
D5 N017 N016 D_VF0p8059
* op-amp 4: A0=100000, GBW=1000000, output limited to [-15, 15]
G_OA4 0 OA4 0 N018 1
R_OA4 OA4 0 100k
C_OA4 OA4 0 159.1549431n
B_OA4 N019 0 V=min(max(V(OA4), -15), 15)
* op-amp 5: A0=100000, GBW=1000000, output limited to [-15, 15]
G_OA5 0 OA5 0 N016 1
R_OA5 OA5 0 100k
C_OA5 OA5 0 159.1549431n
B_OA5 N017 0 V=min(max(V(OA5), -15), 15)
Q4 N018 0 N014 QNPN_100
R14 N018 N019 100k
C4 N018 N019 1u IC=1m
R15 N019 N016 100k
V3 N006 0 PULSE(-5 5 0 2.5u 2.5u 12.5m 25m)
.model D_VF0p8059 D(Is=1.71435e-07 N=2 Rs=0.001 Cjo=1p)
.model QNPN_100 NPN(BF=100 BR=1 IS=1e-13 Cje=1p Cjc=1p)
.tran 5u 768m 0 5u uic
.end
