* eclnor
* Converted from CircuitJS by eetree.cn/tools - open in LTspice (File > Open, then Run)
Q1 N002 N001 N003 QNPN_100
Q2 N002 N004 N003 QNPN_100
R1 N003 N005 1.18k
Q3 N007 N006 N003 QNPN_100
R2 N002 0 217
R3 0 N007 240
Q4 0 N008 N006 QNPN_100
R4 0 N008 250
D1 N008 N009 D_VF0p8059
D2 N009 N010 D_VF0p8059
R5 N010 N005 2.46k
Q5 0 N007 N011 QNPN_100
Q6 0 N002 N012 QNPN_100
R6 N011 N005 1.5k
R7 N012 N005 1.5k
R8 N006 N005 2.96k
V1 N005 0 -5.2
* logic input L
V2 N001 0 -1.4
* logic input L
V3 N004 0 -1.4
.model D_VF0p8059 D(Is=1.71435e-07 N=2 Rs=0.001 Cjo=1p)
.model QNPN_100 NPN(BF=100 BR=1 IS=1e-13 Cje=1p Cjc=1p)
.tran 5u 768m 0 5u uic
.end
