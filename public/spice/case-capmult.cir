* capmult
* Converted from CircuitJS by eetree.cn/tools - open in LTspice (File > Open, then Run)
* Suggested traces: V(N004,N005) V(N002)
* op-amp 1: A0=100000, GBW=1000000.0, output limited to [-15.0, 15.0]
G_OA1 0 OA1 N002 N001 1
R_OA1 OA1 0 100k
C_OA1 OA1 0 159.1549431n
B_OA1 N001 0 V=min(max(V(OA1), -15), 15)
R1 N001 N003 1k
R2 N003 N002 100k
C1 N002 0 100n IC=2.311487919
V1 N003 0 PULSE(-5 5 0 3.333333333u 3.333333333u 16.66666667m 33.33333333m)
V2 N004 0 PULSE(-5 5 0 3.333333333u 3.333333333u 16.66666667m 33.33333333m)
C2 N004 N005 10u IC=2.311487919
R3 N005 0 1k
.tran 5u 768m 0 5u uic
.end
