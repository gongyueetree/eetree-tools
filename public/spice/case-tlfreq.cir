* tlfreq
* Converted from CircuitJS by eetree.cn/tools - open in LTspice (File > Open, then Run)
* Suggested traces: V(N001,N002) V(N003,N004)
V1 N001 0 DC 0 AC 5
R1 N001 N002 75
V2 N003 0 DC 0 AC 5
R2 N003 N004 75
T1 N004 0 0 0 Z0=75 Td=5n
T2 N002 0 N005 0 Z0=75 Td=5n
.ac dec 100 100meg 500meg
.end
