* tlmismatch
* Converted from CircuitJS by eetree.cn/tools - open in LTspice (File > Open, then Run)
T1 N002 N001 N003 0 Z0=75 Td=10n
T2 N003 0 N004 0 Z0=500 Td=10n
T3 N004 0 N005 0 Z0=75 Td=10n
R1 N002 N006 75
R2 N005 0 75
V1 N006 N001 PULSE(0 5 0 10p 10p 3n 100n)
* floating sub-circuit: reference to ground as in CircuitJS
R3 N002 0 100meg
.tran 38.4p 768n 0 38.4p uic
.end
