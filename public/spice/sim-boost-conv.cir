# eetree-sim 1
# name boost-conv
# param VIN 5
# param F 500000
# param DUTY 0.6
# param L1 1e-05
# param C2 2.2e-05
# param RL 24
# param C1 1e-05
# param VT 2
# param KB 20
# param VO 12
# let dt = 1/F/200
# let sp = 20
* boost-conv
* Converted from CircuitJS by eetree.cn/tools - open in LTspice (File > Open, then Run)
* Suggested traces: I(L1) V(VOUT)
.param C1=${C1} C2=${C2} L1=${L1} RL=${RL} VIN=${VIN}
C1 vin 0 {C1} IC=0
L1 vin N001 {L1} IC=0
D1 N001 VOUT D_VF0p35
C2 VOUT 0 {C2} IC=0
RL VOUT 0 {RL}
VIN vin 0 {VIN}
V1 N002 0 PULSE(${(((10)+(0))/2)-(((10)-(0))/2)} ${(((10)+(0))/2)+(((10)-(0))/2)} 0 ${1/(F)*1e-4} ${1/(F)*1e-4} ${(DUTY)/(F)} ${1/(F)})
M1 N001 N002 0 0 MN_1
.model D_VF0p35 D(Is=0.00115374 N=2 Rs=0.001 Cjo=1p)
.model MN_1 NMOS(Level=1 VTO=${1*(VT)} KP=${KB})
.tran ${max((dt),(dt)*153600/200000)} ${(dt)*153600} 0 ${max((dt),(dt)*153600/200000)} uic
.end
