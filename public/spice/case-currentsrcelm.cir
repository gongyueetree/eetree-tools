* currentsrcelm
* Converted from CircuitJS by eetree.cn/tools - open in LTspice (File > Open, then Run)
* Suggested traces: V(N001)
* switch closed
R1 N001 N002 1m
* switch open
R2 N001 N003 1e12
R3 N002 N004 100
R4 N003 N004 400
R5 N001 N004 4k
* switch closed
R6 N004 N005 1m
R7 N004 0 600
R8 N005 0 200
* switch closed
R9 N004 0 1m
I1 0 N001 10m
.tran 5u 384m 0 5u uic
.end
