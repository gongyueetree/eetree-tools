* mux3state
* Converted from CircuitJS by eetree.cn/tools - open in LTspice (File > Open, then Run)
* logic gate (output 5 V, threshold 2.5 V, ~1 ns delay)
B1 B1x 0 V=5*(1-(u(V(N001)-2.5)*u(V(N002)-2.5)))
RB1 B1x B1y 1k
CB1 B1y 0 1p IC=5
B1o N003 0 V=V(B1y)
* logic gate (output 5 V, threshold 2.5 V, ~1 ns delay)
B2 B2x 0 V=5*(u(V(N002)-2.5)*u(V(N004)-2.5))
RB2 B2x B2y 1k
CB2 B2y 0 1p IC=5
B2o N005 0 V=V(B2y)
M1 N006 N005 0 0 MN_1p5_20m
M2 N006 N003 N007 N007 MP_1p5_20m
V1 N007 0 5
* logic input L
V2 N001 0 0
M3 N006 N008 0 0 MN_1p5_20m
M4 N006 N009 N010 N010 MP_1p5_20m
V3 N010 0 5
* logic gate (output 5 V, threshold 2.5 V, ~1 ns delay)
B3 B3x 0 V=5*(u(V(N011)-2.5)*u(V(N012)-2.5))
RB3 B3x B3y 1k
CB3 B3y 0 1p IC=0
B3o N008 0 V=V(B3y)
* logic gate (output 5 V, threshold 2.5 V, ~1 ns delay)
B4 B4x 0 V=5*(1-(u(V(N012)-2.5)*u(V(N013)-2.5)))
RB4 B4x B4y 1k
CB4 B4y 0 1p IC=5
B4o N009 0 V=V(B4y)
* logic gate (output 5 V, threshold 2.5 V, ~1 ns delay)
B5 B5x 0 V=5*(1-u(V(N013)-2.5))
RB5 B5x B5y 1k
CB5 B5y 0 1p IC=0
B5o N011 0 V=V(B5y)
* logic input L
V4 N013 0 0
* logic input L
V5 N012 0 0
* logic gate (output 5 V, threshold 2.5 V, ~1 ns delay)
B6 B6x 0 V=5*(1-u(V(N012)-2.5))
RB6 B6x B6y 1k
CB6 B6y 0 1p IC=0
B6o N002 0 V=V(B6y)
* logic gate (output 5 V, threshold 2.5 V, ~1 ns delay)
B7 B7x 0 V=5*(1-u(V(N001)-2.5))
RB7 B7x B7y 1k
CB7 B7y 0 1p IC=0
B7o N004 0 V=V(B7y)
.model MN_1p5_20m NMOS(Level=1 VTO=1.5 KP=20m)
.model MP_1p5_20m PMOS(Level=1 VTO=-1.5 KP=20m)
.tran 5u 768m 0 5u uic
.end
