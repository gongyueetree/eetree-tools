* diodeclip
* Converted from CircuitJS by eetree.cn/tools - open in LTspice (File > Open, then Run)
* Suggested traces: V(N001) V(N002)
R1 N001 N002 200
R2 N002 N003 100
D1 N003 N004 D_VF0p8059
V1 N004 0 5
V2 N001 0 PULSE(-10 10 0 12.5m 12.5m 0 25m)
.model D_VF0p8059 D(Is=1.71435e-07 N=2 Rs=0.001 Cjo=1p)
.tran 5u 768m 0 5u uic
.end
