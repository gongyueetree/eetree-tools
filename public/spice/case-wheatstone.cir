* wheatstone
* Converted from CircuitJS by eetree.cn/tools - open in LTspice (File > Open, then Run)
V1 N001 0 5
R1 N002 N001 200
R2 N001 N003 400
R3 N002 0 100
R4 0 N003 200
* ammeter (0 V source)
V2 N002 N003 0
.tran 5u 768m 0 5u uic
.end
