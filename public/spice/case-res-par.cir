* res-par
* Converted from CircuitJS by eetree.cn/tools - open in LTspice (File > Open, then Run)
* Suggested traces: V(N003,N004) V(N001) V(N006,N007)
V1 N001 0 SIN(0 5 41.09 0 0 0)
C1 N001 N002 15u IC=2.56584967
L1 N001 N002 1 IC=-16.5088218m
R1 N001 N002 2k
R2 0 N002 100
V2 N004 N003 SIN(0 5 30 0 0 0)
C2 N004 N005 15u IC=-4.290086413
L2 N004 N005 1 IC=13.34973083m
R3 N004 N005 2k
R4 N003 N005 100
V3 N007 N006 SIN(0 5 50 0 0 0)
C3 N007 N008 15u IC=2.932258367
L3 N007 N008 1 IC=-12.79067134m
R5 N007 N008 2k
R6 N006 N008 100
* floating sub-circuit: reference to ground as in CircuitJS
R7 N004 0 100meg
* floating sub-circuit: reference to ground as in CircuitJS
R8 N007 0 100meg
.tran 5u 768m 0 5u uic
.end
