* leadingedge
* Converted from CircuitJS by eetree.cn/tools - open in LTspice (File > Open, then Run)
* Suggested traces: V(N007) V(N009)
M1 N002 N001 N003 N003 MP_1p5_20m
M2 N002 N001 0 0 MN_1p5_20m
V1 N003 0 5
M3 N005 N004 N006 N006 MP_1p5_20m
M4 N005 N004 0 0 MN_1p5_20m
V2 N006 0 5
C1 N002 N004 1n IC=221.6557345m
R1 N004 0 1k
M5 N001 N007 0 0 MN_1p5_20m
M6 N001 N007 N008 N008 MP_1p5_20m
V3 N008 0 5
M7 N009 N005 0 0 MN_1p5_20m
M8 N009 N005 N010 N010 MP_1p5_20m
V4 N010 0 5
V5 N007 0 PULSE(0 5 0 500p 500p 2.5u 5u)
.model MN_1p5_20m NMOS(Level=1 VTO=1.5 KP=20m)
.model MP_1p5_20m PMOS(Level=1 VTO=-1.5 KP=20m)
.tran 4n 307.2u 0 4n uic
.end
