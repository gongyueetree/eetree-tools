* ladder
* Converted from CircuitJS by eetree.cn/tools - open in LTspice (File > Open, then Run)
* Suggested traces: V(N001) V(N022)
V1 N001 0 PULSE(0 5 0 2.5u 2.5u 12.5m 25m)
L1 N001 N002 10m IC=0
L2 N002 N003 10m IC=0
L3 N003 N004 10m IC=0
L4 N004 N005 10m IC=0
L5 N005 N006 10m IC=0
L6 N006 N007 10m IC=0
L7 N007 N008 10m IC=0
C1 N002 0 100u IC=0
C2 N003 0 100u IC=0
C3 N004 0 100u IC=0
C4 N005 0 100u IC=0
C5 N006 0 100u IC=0
C6 N007 0 100u IC=0
C7 N008 0 100u IC=0
L8 N008 N009 10m IC=0
C8 N009 0 100u IC=0
L9 N009 N010 10m IC=0
L10 N010 N011 10m IC=0
L11 N011 N012 10m IC=0
L12 N012 N013 10m IC=0
L13 N013 N014 10m IC=0
L14 N014 N015 10m IC=0
C9 N010 0 100u IC=0
C10 N011 0 100u IC=0
C11 N012 0 100u IC=0
C12 N013 0 100u IC=0
C13 N014 0 100u IC=0
C14 N015 0 100u IC=0
L15 N015 N016 10m IC=0
C15 N016 0 100u IC=0
L16 N016 N017 10m IC=0
L17 N017 N018 10m IC=0
L18 N018 N019 10m IC=0
L19 N019 N020 10m IC=0
L20 N020 N021 10m IC=0
L21 N021 N022 10m IC=0
C16 N017 0 100u IC=0
C17 N018 0 100u IC=0
C18 N019 0 100u IC=0
C19 N020 0 100u IC=0
C20 N021 0 100u IC=0
C21 N022 0 100u IC=0
R1 N022 0 10
.tran 5u 768m 0 5u uic
.end
