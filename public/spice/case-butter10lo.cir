* butter10lo
* Converted from CircuitJS by eetree.cn/tools - open in LTspice (File > Open, then Run)
* Suggested traces: V(N003)
C1 N001 0 5.905164625u IC=4.062633211
L1 N002 N001 12.44865919m IC=53.14007868m
R1 N003 0 50
V1 N002 0 DC 0 AC 5
C2 N004 0 5.369543031u IC=5.125708303
L2 N001 N004 14.42033311m IC=98.32852911m
C3 N005 0 4.112858199u IC=4.157511983
L3 N004 N005 12.01617865m IC=96.06883211m
C4 N006 0 2.427517294u IC=2.71755329
L4 N005 N006 8.28098597m IC=68.09087838m
C5 N003 0 497.9463676n IC=1.943410187
L5 N006 N003 3.70336951m IC=44.19890623m
.ac dec 100 100 2k
.end
