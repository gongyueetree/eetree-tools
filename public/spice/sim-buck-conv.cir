# eetree-sim 1
# name buck-conv
# param VIN 12
# param F 500000
# param DUTY 0.45
# param L1 1e-05
# param C2 2.2e-05
# param RL 2.5
# param C1 1e-05
# param VT 2
# param KB 20
# param VO 5
# let dt = 1/F/200
# let sp = 20
* buck-conv
* Converted from CircuitJS by eetree.cn/tools - open in LTspice (File > Open, then Run)
* Suggested traces: I(L1) V(VOUT)
.param C1=${C1} C2=${C2} L1=${L1} RL=${RL} VIN=${VIN}
C1 vin 0 {C1} IC=0
D1 0 N001 D_VF0p35
L1 N001 VOUT {L1} IC=0
C2 VOUT 0 {C2} IC=0
RL VOUT 0 {RL}
VIN vin 0 {VIN}
V1 N002 0 PULSE(${(((VIN+10)+(0))/2)-(((VIN+10)-(0))/2)} ${(((VIN+10)+(0))/2)+(((VIN+10)-(0))/2)} 0 ${1/(F)*1e-4} ${1/(F)*1e-4} ${(DUTY)/(F)} ${1/(F)})
M1 vin N002 N001 N001 MN_1
.model D_VF0p35 D(Is=0.00115374 N=2 Rs=0.001 Cjo=1p)
.model MN_1 NMOS(Level=1 VTO=${1*(VT)} KP=${KB})
.tran ${max((dt),(dt)*153600/200000)} ${(dt)*153600} 0 ${max((dt),(dt)*153600/200000)} uic
.end
