* spikegen
* Converted from CircuitJS by eetree.cn/tools - open in LTspice (File > Open, then Run)
* Suggested traces: V(N003)
V1 N001 0 PULSE(-5 5 0 2.5u 2.5u 12.5m 25m)
R1 N002 0 110
D1 N002 N003 D_VF0p8059
C1 N001 N002 10u IC=4.986840376
R2 N003 0 100
.model D_VF0p8059 D(Is=1.71435e-07 N=2 Rs=0.001 Cjo=1p)
.tran 5u 768m 0 5u uic
.end
