# eetree-sim 1
# name opamp-relax
# param R1 10000
# param R2 10000
# param R3 10000
# param C1 1e-07
# param VOH 10.5
# param VOL -10.5
# let VR = max(VOH, -VOL, 1)
# let B = R2/(R1+R2)
# let T = R3*C1*(log((VOH-B*VOL)/(VOH-B*VOH)) + log((VOL-B*VOH)/(VOL-B*VOL)))
# let dt = T/1024
# let sp = 6.4
* opamp-relax
* Converted from CircuitJS by eetree.cn/tools - open in LTspice (File > Open, then Run)
* Suggested traces: V(VOUT)
.param C1=${C1} R1=${R1} R2=${R2} R3=${R3} VOH=${VOH} VOL=${VOL}
R3 N001 VOUT {R3}
C1 N001 0 {C1} IC=1
R1 N002 VOUT {R1}
R2 N002 0 {R2}
* op-amp 1: A0=100000, GBW=1000000, output limited to [${VOL}, ${VOH}]
G_OA1 0 OA1 N002 N001 1
R_OA1 OA1 0 100k
C_OA1 OA1 0 159.1549431n
B_OA1 VOUT 0 V=min(max(V(OA1), {VOL}), {VOH})
.tran ${max((dt),(dt)*19200/200000)} ${(dt)*19200} 0 ${max((dt),(dt)*19200/200000)} uic
.end
