* 555int
* Converted from CircuitJS by eetree.cn/tools - open in LTspice (File > Open, then Run)
* Suggested traces: V(N001) V(N011)
* op-amp 1: A0=100000, GBW=1000000, output limited to [0, 5]
G_OA1 0 OA1 N002 N001 1
R_OA1 OA1 0 100k
C_OA1 OA1 0 159.1549431n
B_OA1 N003 0 V=min(max(V(OA1), 0), 5)
* op-amp 2: A0=100000, GBW=1000000, output limited to [0, 5]
G_OA2 0 OA2 N001 N004 1
R_OA2 OA2 0 100k
C_OA2 OA2 0 159.1549431n
B_OA2 N005 0 V=min(max(V(OA2), 0), 5)
R1 N006 N004 5k
R2 N004 N002 5k
R3 N002 0 5k
V1 N006 0 10
V2 N007 0 10
R4 N007 N008 10k
R5 N008 N001 10k
C1 N001 0 300n IC=3.701414575
R6 N009 N010 10k
* logic gate (output 5 V, threshold 2.5 V, ~1 ns delay)
B1 B1x 0 V=5*(1-(1-(1-u(V(N005)-2.5))*(1-u(V(N010)-2.5))))
RB1 B1x B1y 1k
CB1 B1y 0 1p IC=5
B1o N011 0 V=V(B1y)
* logic gate (output 5 V, threshold 2.5 V, ~1 ns delay)
B2 B2x 0 V=5*(1-(1-(1-u(V(N011)-2.5))*(1-u(V(N003)-2.5))))
RB2 B2x B2y 1k
CB2 B2y 0 1p IC=0
B2o N010 0 V=V(B2y)
Q1 N008 N009 0 QNPN_100
.model QNPN_100 NPN(BF=100 BR=1 IS=1e-13 Cje=1p Cjc=1p)
.tran 5u 384m 0 5u uic
.end
