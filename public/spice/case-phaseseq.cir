* phaseseq
* Converted from CircuitJS by eetree.cn/tools - open in LTspice (File > Open, then Run)
* Suggested traces: V(N005) V(N009) V(N016) V(N018)
R1 N001 N002 100
R2 N002 N003 100
R3 N003 N004 100
R4 N004 N005 100
C1 N002 N001 40u IC=-107.4110088m
C2 N003 N006 20u IC=1.113361557
C3 N004 N007 10u IC=-764.7587215m
C4 N005 N008 5u IC=-2.064640714
R5 N001 N006 100
R6 N006 N007 100
R7 N007 N008 100
R8 N008 N009 100
C5 N006 N010 40u IC=-2.88084892
C6 N007 N011 20u IC=-1.973315839
C7 N008 N012 10u IC=-2.770585096
C8 N009 N013 5u IC=-3.374582374
C9 N011 N010 40u IC=107.4110088m
C10 N012 N014 20u IC=-1.113361557
C11 N013 N015 10u IC=764.7587215m
C12 N016 N017 5u IC=2.064640714
R9 N010 N011 100
R10 N011 N012 100
R11 N012 N013 100
R12 N013 N016 100
R13 N018 N017 100
R14 N017 N015 100
R15 N015 N014 100
R16 N014 N010 100
C13 N014 N001 40u IC=2.88084892
C14 N015 N002 20u IC=1.973315839
C15 N017 N003 10u IC=2.770585096
C16 N018 N004 5u IC=3.374582374
V1 N001 0 SIN(0 5 40 0 0 0)
V2 0 N010 SIN(0 5 40 0 0 0)
.tran 20u 1.536 0 20u uic
.end
