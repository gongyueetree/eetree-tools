* ceamp
* Converted from CircuitJS by eetree.cn/tools - open in LTspice (File > Open, then Run)
* Suggested traces: V(N005) V(N006)
R1 N001 N002 110k
R2 N002 0 10k
Q1 N003 N002 N004 QNPN_100
V1 N001 0 20
R3 N001 N003 10k
R4 N004 0 1k
C1 N002 N005 5u IC=1.554237516
V2 N005 0 SIN(0 500m 80 0 0 0)
C2 N003 N006 5u IC=10.0885188
R5 N006 0 1meg
.model QNPN_100 NPN(BF=100 BR=1 IS=1e-13 Cje=1p Cjc=1p)
.tran 5u 768m 0 5u uic
.end
