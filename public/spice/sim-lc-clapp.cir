# eetree-sim 1
# name lc-clapp
# param L1 0.0001
# param C1 2.2e-09
# param C2 1e-08
# param C3 2.2e-10
# let f = 1/(2*PI*sqrt(L1/(1/C1+1/C2+1/C3)))
# let Cc = 1/(2*PI*f*25)
# let Cb = 1/(2*PI*f*25)
# let CE = 1/(2*PI*f*2)
# let dt = 1/(f*200)
# let sp = 5
* lc-clapp
* Converted from CircuitJS by eetree.cn/tools - open in LTspice (File > Open, then Run)
* Suggested traces: V(OUT)
.param C1=${C1} C2=${C2} C3=${C3} CE=${CE} Cb=${Cb} Cc=${Cc} L1=${L1}
R1 N001 N002 47k
R2 N002 0 10k
V1 N001 0 12
R3 N003 N004 2.2k
V2 N003 0 12
R4 N005 0 1k
CE N005 0 {CE} IC=0
Cc N004 OUT {Cc} IC=0
C1 OUT 0 {C1} IC=0
C2 N006 0 {C2} IC=0
L1 OUT N007 {L1} IC=0
C3 N007 N006 {C3} IC=0
Cb N006 N002 {Cb} IC=0
Q1 N004 N002 N005 QNPN_100
.model QNPN_100 NPN(BF=100 BR=1 IS=1e-13 Cje=1p Cjc=1p)
.tran ${max((dt),(dt)*4800/200000)} ${(dt)*4800} 0 ${max((dt),(dt)*4800/200000)} uic
.end
