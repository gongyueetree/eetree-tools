* howland
* Converted from CircuitJS by eetree.cn/tools - open in LTspice (File > Open, then Run)
* Suggested traces: V(N002,N002)
* op-amp 1: A0=100000, GBW=1000000, output limited to [-15.0, 15.0]
G_OA1 0 OA1 N002 N001 1
R_OA1 OA1 0 100k
C_OA1 OA1 0 159.1549431n
B_OA1 N003 0 V=min(max(V(OA1), -15), 15)
R1 N002 N003 3k
R2 N001 N003 5k
R3 N001 N004 5k
R4 0 N002 3k
V1 N004 0 -5
R5 N002 0 2k
* switch open
R6 N002 0 1e12
.tran 5u 768m 0 5u uic
.end
