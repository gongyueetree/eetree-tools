* powerfactor2
* Converted from CircuitJS by eetree.cn/tools - open in LTspice (File > Open, then Run)
* Suggested traces: V(N001,N002) V(N002,N003) I(L1)
V1 N001 0 SIN(0 169.7056275 60 0 0 90)
R1 N002 N003 10
L1 N003 0 5 IC=84.38601285m
R2 N001 N002 50
C1 N002 0 1.4u IC=0
.tran 5u 768m 0 5u uic
.end
