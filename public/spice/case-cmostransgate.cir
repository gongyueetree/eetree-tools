* cmostransgate
* Converted from CircuitJS by eetree.cn/tools - open in LTspice (File > Open, then Run)
* Suggested traces: V(N002)
V1 N001 0 SIN(2.5 2.5 40 0 0 0)
R1 N002 0 1k
* logic gate (output 5 V, threshold 2.5 V, ~1 ns delay)
B1 B1x 0 V=5*(1-u(V(N003)-2.5))
RB1 B1x B1y 1k
CB1 B1y 0 1p IC=0
B1o N004 0 V=V(B1y)
* logic input H
V2 N003 0 5
V3 N005 0 5
M1 N001 N004 N002 N005 MP_1p5_20m
D1 N001 N002 D_body
M2 N002 N003 N001 0 MN_1p5_20m
D2 N001 N002 D_body
.model D_body D(Is=1.7143528192808883e-7 N=2 Rs=1m Cjo=1p)
.model MN_1p5_20m NMOS(Level=1 VTO=1.5 KP=20m)
.model MP_1p5_20m PMOS(Level=1 VTO=-1.5 KP=20m)
.tran 5u 768m 0 5u uic
.end
