* currentsrc
* Converted from CircuitJS by eetree.cn/tools - open in LTspice (File > Open, then Run)
Q1 N002 N001 N003 QNPN_100
R1 N003 0 1k
V1 N004 0 10
* switch open
R2 N004 N002 1e12
R3 N004 N002 6k
R4 N001 0 2k
R5 N001 N004 8k
.model QNPN_100 NPN(BF=100 BR=1 IS=1e-13 Cje=1p Cjc=1p)
.tran 5u 768m 0 5u uic
.end
