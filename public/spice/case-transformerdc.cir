* transformerdc
* Converted from CircuitJS by eetree.cn/tools - open in LTspice (File > Open, then Run)
* Suggested traces: V(N001) V(N003)
V1 N001 0 10
L1 N002 0 10
L2 N003 0 10
K1 L1 L2 999m
R1 N002 N001 100
R2 N003 0 300
.tran 5u 768m 0 5u uic
.end
