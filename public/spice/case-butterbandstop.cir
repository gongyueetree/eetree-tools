* butterbandstop
* Converted from CircuitJS by eetree.cn/tools - open in LTspice (File > Open, then Run)
* Suggested traces: V(N001)
R1 N001 0 50
V1 N002 0 DC 0 AC 5
C1 N002 N003 1.08821849u IC=-1.034667445
C2 N004 0 6.655252268u IC=-23.9626923m
L1 N002 N003 14.23156671m IC=-41.50793393m
L2 N003 N004 2.327042373m IC=2.688353678m
C3 N003 N005 982.4564642n IC=-19.49540985m
C4 N006 0 5.574435271u IC=-628.7696109u
L3 N003 N005 15.76360337m IC=43.86001001u
L4 N005 N006 2.778228337m IC=-11.94371791u
C5 N005 N007 1.349204634u IC=89.37997895u
C6 N008 0 3.417830809u IC=5.551722096u
L5 N005 N007 11.47865464m IC=2.087663682u
L6 N007 N008 4.531252393m IC=-977.1987995n
C7 N007 N001 2.940700012u IC=25.35080431u
C8 N009 0 711.5783356n IC=-7.114634442u
L7 N007 N001 5.266451515m IC=-485.7200787n
L8 N001 N009 21.76436979m IC=301.6835901n
.ac dec 100 20 4k
.end
