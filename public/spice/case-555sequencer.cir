* 555sequencer
* Converted from CircuitJS by eetree.cn/tools - open in LTspice (File > Open, then Run)
* Suggested traces: V(N006) V(N005) V(N010) V(N014)
* 555 timer 1 (CircuitJS TimerElm behaviour)
R_555a1 N003 N004 5k
R_555b1 N004 0 10k
B_555q1 Q555_1x 0 V=(u(V(N004,0)/2-V(N002,0))+(1-u(V(N004,0)/2-V(N002,0)))*(1-u(V(N001)-V(N004)))*u(V(Q555_1)-0.5))*u(V(N003,0)-0.7)
R_555q1 Q555_1x Q555_1 1k
C_555q1 Q555_1 0 1p
B_555o1 Q555_1o 0 V=V(0)+V(Q555_1)*V(N003,0)
R_555o1 Q555_1o N005 1
B_555d1 N001 0 I=(1-V(Q555_1))*V(N001,0)/10
C1 N001 0 2u IC=49.5049505m
R1 N001 N003 1k
R2 N002 N003 100
C2 N002 N006 10u IC=18.22381251u
* logic input H
V1 N006 0 5
V2 N003 0 5
C3 N005 N007 10u IC=-4.999514172
R3 N003 N007 100
R4 N003 N008 1k
* 555 timer 2 (CircuitJS TimerElm behaviour)
R_555a2 N003 N009 5k
R_555b2 N009 0 10k
B_555q2 Q555_2x 0 V=(u(V(N009,0)/2-V(N007,0))+(1-u(V(N009,0)/2-V(N007,0)))*(1-u(V(N008)-V(N009)))*u(V(Q555_2)-0.5))*u(V(N003,0)-0.7)
R_555q2 Q555_2x Q555_2 1k
C_555q2 Q555_2 0 1p
B_555o2 Q555_2o 0 V=V(0)+V(Q555_2)*V(N003,0)
R_555o2 Q555_2o N010 1
B_555d2 N008 0 I=(1-V(Q555_2))*V(N008,0)/10
C4 N008 0 2u IC=49.5049505m
C5 N010 N011 10u IC=-4.995773093
R5 N011 N003 100
R6 N003 N012 1k
* 555 timer 3 (CircuitJS TimerElm behaviour)
R_555a3 N003 N013 5k
R_555b3 N013 0 10k
B_555q3 Q555_3x 0 V=(u(V(N013,0)/2-V(N011,0))+(1-u(V(N013,0)/2-V(N011,0)))*(1-u(V(N012)-V(N013)))*u(V(Q555_3)-0.5))*u(V(N003,0)-0.7)
R_555q3 Q555_3x Q555_3 1k
C_555q3 Q555_3 0 1p
B_555o3 Q555_3o 0 V=V(0)+V(Q555_3)*V(N003,0)
R_555o3 Q555_3o N014 1
B_555d3 N012 0 I=(1-V(Q555_3))*V(N012,0)/10
C6 N012 0 2u IC=49.5049505m
.tran 5u 192m 0 5u uic
.end
