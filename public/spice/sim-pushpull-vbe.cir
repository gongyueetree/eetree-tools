# eetree-sim 1
# name pushpull-vbe
# param VCC 15
# param RL 8
# param VP 10
# param F 1000
# param BETA 100
# param R1 680
# param R2 680
# param R3 1200
# param R4 1000
# param RE1 0.22
# param RE2 0.22
# param VBB 1.3
# let dt = 1/F/400
# let sp = 5
* pushpull-vbe
* Converted from CircuitJS by eetree.cn/tools - open in LTspice (File > Open, then Run)
* Suggested traces: V(vp) V(VOUT)
.param F=${F} R1=${R1} R2=${R2} R3=${R3} R4=${R4} RE1=${RE1} RE2=${RE2} RL=${RL} VCC=${VCC} VP=${VP}
RE1 N001 VOUT {RE1}
RE2 VOUT N002 {RE2}
VCC vcc 0 {VCC}
V1 N003 0 ${-VCC}
RL VOUT 0 {RL}
R3 N004 N005 {R3}
R4 N005 vp {R4}
R1 N006 N004 {R1}
R2 vp N007 {R2}
V2 N006 0 {VCC}
V3 N007 0 ${-VCC}
V4 vp 0 SIN(${-VBB/2} {VP} {F} 0 0 0)
Q1 vcc N004 N001 QNPN_100
Q2 N003 vp N002 QPNP_100
Q3 N004 N005 vp QNPN_100
.model QNPN_100 NPN(BF=100 BR=1 IS=1e-13 Cje=1p Cjc=1p)
.model QPNP_100 PNP(BF=100 BR=1 IS=1e-13 Cje=1p Cjc=1p)
.tran ${max((dt),(dt)*4800/200000)} ${(dt)*4800} 0 ${max((dt),(dt)*4800/200000)} uic
.end
