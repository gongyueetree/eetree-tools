* nic-r
* Converted from CircuitJS by eetree.cn/tools - open in LTspice (File > Open, then Run)
* Suggested traces: V(N002) V(N004)
* op-amp 1: A0=100000, GBW=1000000, output limited to [-15, 15]
G_OA1 0 OA1 N002 N001 1
R_OA1 OA1 0 100k
C_OA1 OA1 0 159.1549431n
B_OA1 N003 0 V=min(max(V(OA1), -15), 15)
R1 N002 N003 100
R2 N001 N003 100
V1 N002 0 SIN(0 5 100 0 0 0)
V2 N004 0 SIN(0 5 100 0 0 0)
R3 N001 0 150
R4 N004 0 150
.tran 5u 768m 0 5u uic
.end
