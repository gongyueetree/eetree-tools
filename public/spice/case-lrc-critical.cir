* lrc-critical
* Converted from CircuitJS by eetree.cn/tools - open in LTspice (File > Open, then Run)
* Suggested traces: I(L1) V(N001,N004) V(N001,N002)
R1 N001 N002 516.4
* switch open
R2 N002 N003 1e12
C1 N001 N004 15u IC=-9.860041922
L1 N002 N004 1 IC=30.19234785m
V1 N003 0 5
R3 N004 0 100
.tran 5u 768m 0 5u uic
.end
