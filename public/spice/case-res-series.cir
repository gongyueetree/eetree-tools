* res-series
* Converted from CircuitJS by eetree.cn/tools - open in LTspice (File > Open, then Run)
* Suggested traces: V(N006,N007) V(N008,N009) V(N010,N011)
V1 N001 0 SIN(0 5 35 0 0 0)
V2 N003 N002 SIN(0 5 41.09 0 0 0)
V3 N005 N004 SIN(0 5 45 0 0 0)
R1 N001 N006 10
C1 N006 N007 15u IC=0
L1 0 N007 1 IC=0
R2 N003 N008 10
C2 N008 N009 15u IC=0
L2 N002 N009 1 IC=0
R3 N005 N010 10
C3 N010 N011 15u IC=0
L3 N004 N011 1 IC=0
* floating sub-circuit: reference to ground as in CircuitJS
R4 N003 0 100meg
* floating sub-circuit: reference to ground as in CircuitJS
R5 N005 0 100meg
.tran 5u 768m 0 5u uic
.end
