* ohms
* Converted from CircuitJS by eetree.cn/tools - open in LTspice (File > Open, then Run)
R1 N001 0 100
V1 N001 0 5
R2 N001 0 1k
.tran 5u 768m 0 5u uic
.end
