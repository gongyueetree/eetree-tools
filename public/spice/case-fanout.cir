* fanout
* Converted from CircuitJS by eetree.cn/tools - open in LTspice (File > Open, then Run)
Q1 N002 N001 N003 QNPN_100
Q2 N004 N002 0 QNPN_100
R1 N001 N005 4.7k
R2 N005 N004 1k
V1 N005 0 5
* logic input L
V2 N003 0 0
* logic input H
V3 N006 0 5
V4 N007 0 5
R3 N007 N008 1k
R4 N009 N007 4.7k
Q3 N008 N010 0 QNPN_100
Q4 N010 N009 N006 QNPN_100
Q5 N012 N011 N008 QNPN_100
Q6 N013 N012 0 QNPN_100
R5 N011 N014 4.7k
R6 N014 N013 1k
V5 N014 0 5
V6 N015 0 5
R7 N015 N016 1k
R8 N017 N015 4.7k
Q7 N016 N018 0 QNPN_100
Q8 N018 N017 N008 QNPN_100
V7 N019 0 5
R9 N019 N020 1k
R10 N021 N019 4.7k
Q9 N020 N022 0 QNPN_100
Q10 N022 N021 N008 QNPN_100
Q11 N024 N023 N008 QNPN_100
Q12 N025 N024 0 QNPN_100
R11 N023 N026 4.7k
R12 N026 N025 1k
V8 N026 0 5
Q13 N028 N027 N008 QNPN_100
Q14 N029 N028 0 QNPN_100
R13 N027 N030 4.7k
R14 N030 N029 1k
V9 N030 0 5
V10 N031 0 5
R15 N031 N032 1k
R16 N033 N031 4.7k
Q15 N032 N034 0 QNPN_100
Q16 N034 N033 N008 QNPN_100
.model QNPN_100 NPN(BF=100 BR=1 IS=1e-13 Cje=1p Cjc=1p)
.tran 5u 768m 0 5u uic
.end
