* multivib-a
* Converted from CircuitJS by eetree.cn/tools - open in LTspice (File > Open, then Run)
* Suggested traces: V(N004,N002)
R1 N001 N002 330
R2 N001 N003 1.02k
R3 N001 N004 1.02k
R4 N001 N005 320
C1 N002 N003 18u IC=3.70240166
C2 N005 N004 18u IC=-557.1050334m
Q1 N005 N003 0 QNPN_100
Q2 N002 N004 0 QNPN_100
V1 N001 0 5
.model QNPN_100 NPN(BF=100 BR=1 IS=1e-13 Cje=1p Cjc=1p)
.tran 5u 768m 0 5u uic
.end
