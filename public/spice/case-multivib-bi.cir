* multivib-bi
* Converted from CircuitJS by eetree.cn/tools - open in LTspice (File > Open, then Run)
R1 N001 N002 100
R2 N001 N003 100
Q1 N003 N004 0 QNPN_100
Q2 N002 N005 0 QNPN_100
R3 N005 N003 1.02k
R4 N002 N004 1.02k
V1 N001 0 5
R5 N005 N006 1k
R6 N004 N007 1k
* logic input L
V2 N006 0 0
* logic input L
V3 N007 0 0
.model QNPN_100 NPN(BF=100 BR=1 IS=1e-13 Cje=1p Cjc=1p)
.tran 5u 768m 0 5u uic
.end
