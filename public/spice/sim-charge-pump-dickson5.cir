# eetree-sim 1
# name charge-pump-dickson5
# param VIN 5
# param f 100000
# param C 1e-06
# param Co 1e-05
# param RL 1000
# let dt = 1/(f*200)
# let sp = 100
* charge-pump-dickson5
* Converted from CircuitJS by eetree.cn/tools - open in LTspice (File > Open, then Run)
* Suggested traces: V(VOUT) V(N002)
.param C=${C} Co=${Co} RL=${RL} VIN=${VIN}
D1 vin N001 D_VF0p35
C N001 N002 {C} IC=0
D2 N001 N003 D_VF0p35
C1 N003 N004 {C} IC=0
D3 N003 N005 D_VF0p35
C2 N005 N006 {C} IC=0
D4 N005 N007 D_VF0p35
C3 N007 N008 {C} IC=0
D5 N007 N009 D_VF0p35
C4 N009 N010 {C} IC=0
D6 N009 VOUT D_VF0p35
Co VOUT 0 {Co} IC=0
RL VOUT 0 {RL}
VIN vin 0 {VIN}
V1 N002 0 PULSE(${(VIN/2)-(VIN/2)} ${(VIN/2)+(VIN/2)} 0 ${1/(f)*1e-4} ${1/(f)*1e-4} ${(0.5)/(f)} ${1/(f)})
V2 N004 0 PULSE(${(VIN/2)-(-VIN/2)} ${(VIN/2)+(-VIN/2)} 0 ${1/(f)*1e-4} ${1/(f)*1e-4} ${(0.5)/(f)} ${1/(f)})
V3 N006 0 PULSE(${(VIN/2)-(VIN/2)} ${(VIN/2)+(VIN/2)} 0 ${1/(f)*1e-4} ${1/(f)*1e-4} ${(0.5)/(f)} ${1/(f)})
V4 N008 0 PULSE(${(VIN/2)-(-VIN/2)} ${(VIN/2)+(-VIN/2)} 0 ${1/(f)*1e-4} ${1/(f)*1e-4} ${(0.5)/(f)} ${1/(f)})
V5 N010 0 PULSE(${(VIN/2)-(VIN/2)} ${(VIN/2)+(VIN/2)} 0 ${1/(f)*1e-4} ${1/(f)*1e-4} ${(0.5)/(f)} ${1/(f)})
.model D_VF0p35 D(Is=0.00115374 N=2 Rs=0.001 Cjo=1p)
.tran ${max((dt),(dt)*614400/200000)} ${(dt)*614400} 0 ${max((dt),(dt)*614400/200000)} uic
.end
