* ttlinverter
* Converted from CircuitJS by eetree.cn/tools - open in LTspice (File > Open, then Run)
Q1 N002 N001 N003 QNPN_100
Q2 N004 N002 0 QNPN_100
* logic input H
V1 N003 0 5
R1 N001 N005 4.7k
R2 N005 N004 1k
V2 N005 0 5
.model QNPN_100 NPN(BF=100 BR=1 IS=1e-13 Cje=1p Cjc=1p)
.tran 5u 768m 0 5u uic
.end
