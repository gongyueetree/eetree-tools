* 3way
* Converted from CircuitJS by eetree.cn/tools - open in LTspice (File > Open, then Run)
V1 N001 0 SIN(0 169.7056275 60 0 0 0)
R1 N002 0 150
* SPDT switch throw 0 off
R2 N001 N003 1e12
* SPDT switch throw 1 on
R3 N001 N004 1m
* SPDT switch throw 0 on
R4 N002 N004 1m
* SPDT switch throw 1 off
R5 N002 N003 1e12
.tran 5u 768m 0 5u uic
.end
