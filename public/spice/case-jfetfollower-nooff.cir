* jfetfollower-nooff
* Converted from CircuitJS by eetree.cn/tools - open in LTspice (File > Open, then Run)
* Suggested traces: V(N003) V(N002)
R1 N001 N002 1.1k
J1 N004 N003 N001 JF_J1
V1 N003 0 SIN(0 2 40 0 0 0)
J2 N002 N005 N006 JF_J2
R2 N006 N005 1.1k
V2 N005 0 -10
V3 N004 0 10
.model JF_J1 NJF(VTO=-4 BETA=625u)
.model JF_J2 NJF(VTO=-4 BETA=625u)
.tran 5u 768m 0 5u uic
.end
