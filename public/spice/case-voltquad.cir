* voltquad
* Converted from CircuitJS by eetree.cn/tools - open in LTspice (File > Open, then Run)
* Suggested traces: V(N003) V(N005)
D1 N001 N002 D_VF0p8059
C1 N003 N004 100u IC=0
D2 N004 N005 D_VF0p8059
C2 N005 0 100u IC=0
R1 N005 0 50k
V1 N003 0 SIN(0 15 120 0 0 0)
D3 0 N001 D_VF0p8059
D4 N002 N004 D_VF0p8059
C3 N002 0 100u IC=0
C4 N003 N001 100u IC=0
.model D_VF0p8059 D(Is=1.71435e-07 N=2 Rs=0.001 Cjo=1p)
.tran 5u 768m 0 5u uic
.end
