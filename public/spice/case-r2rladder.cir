* r2rladder
* Converted from CircuitJS by eetree.cn/tools - open in LTspice (File > Open, then Run)
* analog switch (on when CTL > 2.5 V)
S1 N001 N002 N003 0 SW_20_10g
S2 N001 0 0 N003 SW_20_10gn
* analog switch (on when CTL > 2.5 V)
S3 N004 N002 N005 0 SW_20_10g
S4 N004 0 0 N005 SW_20_10gn
* analog switch (on when CTL > 2.5 V)
S5 N006 N002 N007 0 SW_20_10g
S6 N006 0 0 N007 SW_20_10gn
* logic input H
V1 N003 0 5
* logic input H
V2 N005 0 5
* logic input L
V3 N007 0 0
R1 N001 N008 100k
R2 N004 N009 100k
R3 N006 N010 100k
R4 N008 N009 50k
R5 N009 N010 50k
R6 N010 0 100k
R7 N002 N011 50.1k
* op-amp 1: A0=100000, GBW=1000000, output limited to [-20.0, 20.0]
G_OA1 0 OA1 0 N002 1
R_OA1 OA1 0 100k
C_OA1 OA1 0 159.1549431n
B_OA1 N011 0 V=min(max(V(OA1), -20), 20)
R8 N008 N012 50k
R9 N012 N013 100k
* analog switch (on when CTL > 2.5 V)
S7 N013 N002 N014 0 SW_20_10g
S8 N013 0 0 N014 SW_20_10gn
* logic input L
V4 N014 0 0
V5 N012 0 16
.model SW_20_10g SW(Ron=20 Roff=10g Vt=2.5 Vh=0)
.model SW_20_10gn SW(Ron=20 Roff=10g Vt=-2.5 Vh=0)
.tran 5u 768m 0 5u uic
.end
