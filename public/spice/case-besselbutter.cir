* besselbutter
* Converted from CircuitJS by eetree.cn/tools - open in LTspice (File > Open, then Run)
* Suggested traces: V(N003) V(N008)
C1 N001 0 6.083084599u IC=-4.999993387
L1 N002 N001 22.66800618m IC=-99.99921211m
R1 N003 0 50
C2 N004 0 4.394812137u IC=-5.000480508
L2 N001 N004 12.56068558m IC=-100.0058297m
C3 N005 0 3.270485695u IC=-4.999333513
L3 N004 N005 9.621226664m IC=-100.0017863m
C4 N006 0 1.926743248u IC=-4.998536841
L4 N005 N006 6.573613745m IC=-99.97485163m
C5 N003 0 395.3712485n IC=-4.99868176
L5 N006 N003 2.940014815m IC=-99.9717806m
L6 N007 N008 3.70336951m IC=-103.3683387m
C6 N008 0 497.9463676n IC=-5.22685356
L7 N009 N007 8.28098597m IC=-97.39160228m
C7 N007 0 2.427517294u IC=-5.045542492
L8 N010 N009 12.01617865m IC=-93.63197456m
C8 N009 0 4.112858199u IC=-4.706292767
L9 N011 N010 14.42033311m IC=-103.0841296m
C9 N010 0 5.369543031u IC=-4.878852156
R2 N008 0 50
L10 N002 N011 12.44865919m IC=-99.50752671m
C10 N011 0 5.905164625u IC=-5.184027929
V1 N002 0 PULSE(-5 5 0 1.25u 1.25u 6.25m 12.5m)
.tran 5u 384m 0 5u uic
.end
