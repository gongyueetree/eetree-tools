* mosfollower
* Converted from CircuitJS by eetree.cn/tools - open in LTspice (File > Open, then Run)
* Suggested traces: V(N002)
V1 N001 0 SIN(0 5 40 0 0 0)
M1 N003 N001 N002 N002 MN_1p5_20m
R1 N004 N003 500
V2 N004 0 15
V3 N005 0 -15
I1 N002 N005 5m
.model MN_1p5_20m NMOS(Level=1 VTO=1.5 KP=20m)
.tran 5u 768m 0 5u uic
.end
