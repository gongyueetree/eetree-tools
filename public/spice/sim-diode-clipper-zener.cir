# eetree-sim 1
# name diode-clipper-zener
# param VP 10
# param f 1000
# param R1 1000
# param RL 100000
# param D1 4.7
# param D2 4.7
# let dt = 1/(f*400)
# let sp = 1.25
* diode-clipper-zener
* Converted from CircuitJS by eetree.cn/tools - open in LTspice (File > Open, then Run)
* Suggested traces: V(vp)
.param R1=${R1} RL=${RL} VP=${VP} f=${f}
R1 vp VOUT {R1}
D1 N001 VOUT DZ_0
D2 N001 0 DZ_1
RL VOUT 0 {RL}
V1 vp 0 SIN(0 {VP} {f} 0 0 0)
.model DZ_0 D(Is=1.71435e-07 N=2 Rs=0.001 Cjo=1p BV=${D1} IBV=5m)
.model DZ_1 D(Is=1.71435e-07 N=2 Rs=0.001 Cjo=1p BV=${D2} IBV=5m)
.tran ${max((dt),(dt)*4800/200000)} ${(dt)*4800} 0 ${max((dt),(dt)*4800/200000)} uic
.end
