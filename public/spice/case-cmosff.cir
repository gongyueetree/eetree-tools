* cmosff
* Converted from CircuitJS by eetree.cn/tools - open in LTspice (File > Open, then Run)
M1 N002 N001 N003 N003 MP_1p5_20m
M2 N002 N001 N004 N004 MN_1p5_20m
M3 N004 N005 0 0 MN_1p5_20m
M4 N002 N005 N003 N003 MP_1p5_20m
V1 N003 0 5
* logic input H
V2 N001 0 5
M5 N005 N006 N003 N003 MP_1p5_20m
M6 N005 N002 N003 N003 MP_1p5_20m
M7 N005 N002 N007 N007 MN_1p5_20m
M8 N007 N006 0 0 MN_1p5_20m
* logic input H
V3 N006 0 5
.model MN_1p5_20m NMOS(Level=1 VTO=1.5 KP=20m)
.model MP_1p5_20m PMOS(Level=1 VTO=-1.5 KP=20m)
.tran 5u 768m 0 5u uic
.end
