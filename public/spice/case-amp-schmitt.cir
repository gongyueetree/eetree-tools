* amp-schmitt
* Converted from CircuitJS by eetree.cn/tools - open in LTspice (File > Open, then Run)
* Suggested traces: V(N001) V(N002)
* op-amp 1: A0=100000, GBW=1000000, output limited to [-15.0, 15.0]
G_OA1 0 OA1 N002 N001 1
R_OA1 OA1 0 100k
C_OA1 OA1 0 159.1549431n
B_OA1 N003 0 V=min(max(V(OA1), -15), 15)
R1 N003 N002 100k
R2 N002 N004 10k
R3 N002 0 10k
V1 N004 0 10
V2 N005 N001 SIN(0 5 40 0 0 0)
V3 N005 0 SIN(5 1 1k 0 0 0)
.tran 5u 768m 0 5u uic
.end
