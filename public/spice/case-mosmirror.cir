* mosmirror
* Converted from CircuitJS by eetree.cn/tools - open in LTspice (File > Open, then Run)
M1 N001 N001 0 0 MN_1p5_20m
M2 N002 N001 0 0 MN_1p5_20m
V1 N003 0 5
V2 N004 0 5
R1 N004 N002 100
* switch open
R2 N004 N002 1e12
R3 N003 N001 500
R4 N003 N005 100
* switch open
R5 N005 N001 1e12
.model MN_1p5_20m NMOS(Level=1 VTO=1.5 KP=20m)
.tran 5u 768m 0 5u uic
.end
