* ttlnor
* Converted from CircuitJS by eetree.cn/tools - open in LTspice (File > Open, then Run)
Q1 N002 N001 N003 QNPN_100
Q2 N004 N002 0 QNPN_100
* logic input H
V1 N003 0 5
R1 N001 N005 4.7k
V2 N005 0 5
Q3 N007 N006 N008 QNPN_100
Q4 N004 N007 0 QNPN_100
R2 N005 N006 4.7k
R3 N005 N004 1k
* logic input L
V3 N008 0 0
R4 N005 N004 1k
.model QNPN_100 NPN(BF=100 BR=1 IS=1e-13 Cje=1p Cjc=1p)
.tran 5u 768m 0 5u uic
.end
