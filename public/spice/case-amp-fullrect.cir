* amp-fullrect
* Converted from CircuitJS by eetree.cn/tools - open in LTspice (File > Open, then Run)
* Suggested traces: V(N004) V(N006)
* op-amp 1: A0=100000, GBW=1000000, output limited to [-15.0, 15.0]
G_OA1 0 OA1 0 N001 1
R_OA1 OA1 0 100k
C_OA1 OA1 0 159.1549431n
B_OA1 N002 0 V=min(max(V(OA1), -15), 15)
D1 N002 N001 D_VF0p8059
D2 N003 N002 D_VF0p8059
R1 N001 N003 1k
R2 N001 N004 1k
R3 N004 N005 1k
R4 N005 N003 500
* op-amp 2: A0=100000, GBW=1000000, output limited to [-15.0, 15.0]
G_OA2 0 OA2 0 N005 1
R_OA2 OA2 0 100k
C_OA2 OA2 0 159.1549431n
B_OA2 N006 0 V=min(max(V(OA2), -15), 15)
R5 N005 N006 1k
V1 N004 0 SIN(0 1 40 0 0 0)
.model D_VF0p8059 D(Is=1.71435e-07 N=2 Rs=0.001 Cjo=1p)
.tran 5u 768m 0 5u uic
.end
