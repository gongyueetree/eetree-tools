* capac
* Converted from CircuitJS by eetree.cn/tools - open in LTspice (File > Open, then Run)
* Suggested traces: V(N002)
V1 N001 0 SIN(0 5 40 0 0 0)
R1 N001 N002 180
C1 N002 0 33u IC=-318.7640178m
.tran 5u 768m 0 5u uic
.end
