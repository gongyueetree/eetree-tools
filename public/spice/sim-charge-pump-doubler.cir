# eetree-sim 1
# name charge-pump-doubler
# param VIN 5
# param f 100000
# param C 1e-06
# param Co 1e-05
# param RL 1000
# let dt = 1/(f*200)
# let sp = 100
* charge-pump-doubler
* Converted from CircuitJS by eetree.cn/tools - open in LTspice (File > Open, then Run)
* Suggested traces: V(VOUT) V(N002)
.param C=${C} Co=${Co} RL=${RL} VIN=${VIN}
D1 vin N001 D_VF0p35
D2 N001 VOUT D_VF0p35
C N001 N002 {C} IC=0
Co VOUT 0 {Co} IC=0
RL VOUT 0 {RL}
VIN vin 0 {VIN}
V1 N002 0 PULSE(${(VIN/2)-(VIN/2)} ${(VIN/2)+(VIN/2)} 0 ${1/(f)*1e-4} ${1/(f)*1e-4} ${(0.5)/(f)} ${1/(f)})
.model D_VF0p35 D(Is=0.00115374 N=2 Rs=0.001 Cjo=1p)
.tran ${max((dt),(dt)*614400/200000)} ${(dt)*614400} 0 ${max((dt),(dt)*614400/200000)} uic
.end
