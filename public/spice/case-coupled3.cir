* coupled3
* Converted from CircuitJS by eetree.cn/tools - open in LTspice (File > Open, then Run)
* Suggested traces: V(N005,N007) V(N012,N014) V(N019,N021)
L1 N001 N002 1 IC=-10.52605453m
L2 N002 N003 1 IC=-14.78085911m
C1 N001 0 10u IC=-1.528335964
C2 N002 N004 10u IC=-622.6471661m
C3 N003 N005 10u IC=622.6471661m
R1 0 N004 1
R2 N004 N005 1
L3 N003 N006 1 IC=-10.52605453m
C4 N006 N007 10u IC=1.528335964
R3 N005 N007 1
L4 N008 N009 1 IC=14.63599891m
L5 N009 N010 1 IC=-7.561108857e-17
C5 N008 0 10u IC=-3.205717865
C6 N009 N011 10u IC=3.205717865
C7 N010 N012 10u IC=3.205717865
R4 0 N011 1
R5 N011 N012 1
L6 N010 N013 1 IC=-14.63599891m
C8 N013 N014 10u IC=-3.205717865
R6 N012 N014 1
L7 N015 N016 1 IC=9.608347545m
L8 N016 N017 1 IC=-13.58826647m
C9 N015 0 10u IC=950.5461008m
C10 N016 N018 10u IC=-2.294822896
C11 N017 N019 10u IC=2.294822896
R7 0 N018 1
R8 N018 N019 1
L9 N017 N020 1 IC=9.608347545m
C12 N020 N021 10u IC=-950.5461008m
R9 N019 N021 1
.tran 7.68u 1.536 0 7.68u uic
.end
