* potdivide
* Converted from CircuitJS by eetree.cn/tools - open in LTspice (File > Open, then Run)
* potentiometer
R1 0 N002 500
R2 N002 N001 500
V1 N001 0 5
.tran 5u 768m 0 5u uic
.end
