* amp-diff
* Converted from CircuitJS by eetree.cn/tools - open in LTspice (File > Open, then Run)
* Suggested traces: V(N004) V(N005) V(N003)
* op-amp 1: A0=100000, GBW=1000000, output limited to [-15.0, 15.0]
G_OA1 0 OA1 N002 N001 1
R_OA1 OA1 0 100k
C_OA1 OA1 0 159.1549431n
B_OA1 N003 0 V=min(max(V(OA1), -15), 15)
R1 N001 N003 1k
R2 N004 N001 1k
R3 N002 0 1k
R4 N002 N005 1k
V1 N004 0 SIN(0 5 60 0 0 0)
V2 N006 N005 PULSE(-1 1 0 833.3333333n 833.3333333n 4.166666667m 8.333333333m)
V3 N006 0 SIN(0 5 60 0 0 0)
.tran 5u 768m 0 5u uic
.end
