* crossover
* Converted from CircuitJS by eetree.cn/tools - open in LTspice (File > Open, then Run)
* Suggested traces: V(N003) V(N007) V(N009)
V1 N001 0 DC 0 AC 5
L1 N001 N002 2.12m IC=-88.81265679m
C1 N002 0 60u IC=-289.4173323m
L2 N002 N003 700u IC=-6.42276796m
R1 N003 0 5.6
C2 N001 N004 21u IC=-839.8710078m
C3 N004 N005 63u IC=90.45561371m
L3 N005 N006 240u IC=684.4180362m
L4 N006 N007 80u IC=661.0256501m
L5 N004 0 1.51m IC=30.77126213m
C4 N006 0 3.32u IC=5.438742671
R2 N007 0 8
C5 N001 N008 2.37u IC=4.767372701
C6 N008 N009 7.1u IC=-162.3541278m
L6 N008 0 150u IC=90.52584172m
R3 N009 0 5.6
.ac dec 100 100 20k
.end
