* voltdouble
* Converted from CircuitJS by eetree.cn/tools - open in LTspice (File > Open, then Run)
* Suggested traces: V(N001) V(N002,N003)
V1 N001 0 SIN(0 15 40 0 0 0)
D1 N001 N002 D_VF0p8059
C1 N002 0 100u IC=0
C2 0 N003 100u IC=0
D2 N003 N001 D_VF0p8059
R1 N002 N003 10k
.model D_VF0p8059 D(Is=1.71435e-07 N=2 Rs=0.001 Cjo=1p)
.tran 5u 768m 0 5u uic
.end
