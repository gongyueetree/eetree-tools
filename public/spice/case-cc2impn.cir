* cc2impn
* Converted from CircuitJS by eetree.cn/tools - open in LTspice (File > Open, then Run)
* op-amp 1: A0=100000, GBW=1000000, output limited to [-15.0, 15.0]
G_OA1 0 OA1 N002 N001 1
R_OA1 OA1 0 100k
C_OA1 OA1 0 159.1549431n
B_OA1 N003 0 V=min(max(V(OA1), -15), 15)
M1 N004 N003 N001 N001 MN_1p5_20m
M2 N005 N003 N001 N001 MP_1p5_20m
M3 N005 N005 N006 N006 MN_1p5_20m
M4 N008 N005 N007 N007 MN_1p5_20m
M5 N004 N004 N009 N009 MP_1p5_20m
M6 N010 N004 N011 N011 MP_1p5_20m
V1 N002 0 2.64
* potentiometer
R1 N012 N013 457.9
R2 N013 N001 42.1
R3 N013 0 100
V2 N009 0 10
V3 N011 0 10
V4 N006 0 -10
V5 N007 0 -10
M7 N008 N008 N014 N014 MP_1p5_20m
M8 N015 N008 N016 N016 MP_1p5_20m
M9 N010 N010 N017 N017 MN_1p5_20m
M10 N015 N010 N018 N018 MN_1p5_20m
V6 N017 0 -10
V7 N018 0 -10
V8 N014 0 10
V9 N016 0 10
R4 N015 0 100
.model MN_1p5_20m NMOS(Level=1 VTO=1.5 KP=20m)
.model MP_1p5_20m PMOS(Level=1 VTO=-1.5 KP=20m)
.tran 5u 768m 0 5u uic
.end
