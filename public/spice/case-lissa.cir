* lissa
* Converted from CircuitJS by eetree.cn/tools - open in LTspice (File > Open, then Run)
* Suggested traces: V(N001) V(N005,N004) V(N009,N008)
V1 N001 0 SIN(0 5 100 0 0 0)
V2 N003 N002 SIN(0 5 104 0 0 0)
V3 N005 N004 SIN(0 5 40 0 0 0)
V4 N007 N006 SIN(0 5 101 0 0 0)
V5 N009 N008 SIN(0 5 91 0 0 0)
V6 N011 N010 SIN(0 5 30 0 0 0)
* floating sub-circuit: reference to ground as in CircuitJS
R1 N003 0 100meg
* floating sub-circuit: reference to ground as in CircuitJS
R2 N005 0 100meg
* floating sub-circuit: reference to ground as in CircuitJS
R3 N007 0 100meg
* floating sub-circuit: reference to ground as in CircuitJS
R4 N009 0 100meg
* floating sub-circuit: reference to ground as in CircuitJS
R5 N011 0 100meg
.tran 5u 768m 0 5u uic
.end
