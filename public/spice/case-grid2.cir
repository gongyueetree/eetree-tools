* grid2
* Converted from CircuitJS by eetree.cn/tools - open in LTspice (File > Open, then Run)
V1 N001 0 5
R1 N002 N003 10
R2 N003 N004 10
R3 N004 N005 10
R4 N005 N006 10
R5 N006 N007 10
R6 N007 N008 10
R7 N008 N009 10
R8 N010 N011 10
R9 N011 N012 10
R10 N012 N013 10
R11 N013 N014 10
R12 N014 N015 10
R13 N015 N016 10
R14 N016 N017 10
R15 N018 N019 10
R16 N019 N020 10
R17 N020 N021 10
R18 N021 N022 10
R19 N022 N023 10
R20 N023 N024 10
R21 N024 N025 10
R22 N026 N027 10
R23 N027 N028 10
R24 N028 N029 10
R25 N029 N030 10
R26 N030 N031 10
R27 N031 N032 10
R28 N032 N033 10
R29 N034 N035 10
R30 N035 N036 10
R31 N036 N037 10
R32 N037 N038 10
R33 N038 N039 10
R34 N039 N040 10
R35 N040 N041 10
R36 N042 N043 10
R37 N043 N044 10
R38 N044 N001 10
R39 0 N045 10
R40 N045 N046 10
R41 N046 N047 10
R42 N048 N049 10
R43 N049 N050 10
R44 N050 N051 10
R45 N051 N052 10
R46 N052 N053 10
R47 N053 N054 10
R48 N054 N055 10
R49 N056 N057 10
R50 N057 N058 10
R51 N058 N059 10
R52 N059 N060 10
R53 N060 N061 10
R54 N061 N062 10
R55 N062 N063 10
R56 N064 N065 10
R57 N065 N066 10
R58 N066 N067 10
R59 N067 N068 10
R60 N068 N069 10
R61 N069 N070 10
R62 N070 N071 10
R63 N072 N073 10
R64 N073 N074 10
R65 N074 N075 10
R66 N075 N076 10
R67 N076 N077 10
R68 N077 N078 10
R69 N078 N079 10
R70 N080 N081 10
R71 N081 N082 10
R72 N082 N083 10
R73 N083 N084 10
R74 N084 N085 10
R75 N085 N086 10
R76 N086 N087 10
R77 N002 N010 10
R78 N003 N011 10
R79 N004 N012 10
R80 N005 N013 10
R81 N006 N014 10
R82 N007 N015 10
R83 N008 N016 10
R84 N009 N017 10
R85 N010 N018 10
R86 N011 N019 10
R87 N012 N020 10
R88 N013 N021 10
R89 N014 N022 10
R90 N015 N023 10
R91 N016 N024 10
R92 N017 N025 10
R93 N018 N026 10
R94 N019 N027 10
R95 N020 N028 10
R96 N021 N029 10
R97 N022 N030 10
R98 N023 N031 10
R99 N024 N032 10
R100 N025 N033 10
R101 N026 N034 10
R102 N027 N035 10
R103 N028 N036 10
R104 N029 N037 10
R105 N030 N038 10
R106 N031 N039 10
R107 N032 N040 10
R108 N033 N041 10
R109 N034 N042 10
R110 N035 N043 10
R111 N036 N044 10
R112 N037 N001 10
R113 N038 0 10
R114 N039 N045 10
R115 N040 N046 10
R116 N041 N047 10
R117 N042 N048 10
R118 N043 N049 10
R119 N044 N050 10
R120 N001 N051 10
R121 0 N052 10
R122 N045 N053 10
R123 N046 N054 10
R124 N047 N055 10
R125 N048 N056 10
R126 N049 N057 10
R127 N050 N058 10
R128 N051 N059 10
R129 N052 N060 10
R130 N053 N061 10
R131 N054 N062 10
R132 N055 N063 10
R133 N056 N064 10
R134 N057 N065 10
R135 N058 N066 10
R136 N059 N067 10
R137 N060 N068 10
R138 N061 N069 10
R139 N062 N070 10
R140 N063 N071 10
R141 N064 N072 10
R142 N065 N073 10
R143 N066 N074 10
R144 N067 N075 10
R145 N068 N076 10
R146 N069 N077 10
R147 N070 N078 10
R148 N071 N079 10
R149 N072 N080 10
R150 N073 N081 10
R151 N074 N082 10
R152 N075 N083 10
R153 N076 N084 10
R154 N077 N085 10
R155 N078 N086 10
R156 N079 N087 10
.tran 5u 768m 0 5u uic
.end
