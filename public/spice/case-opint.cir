* opint
* Converted from CircuitJS by eetree.cn/tools - open in LTspice (File > Open, then Run)
* Suggested traces: V(N001) V(N018)
Q1 N002 N001 N003 QNPN_100
Q2 N005 N004 N003 QPNP_100
Q3 N006 N005 N007 QNPN_100
Q4 N005 N007 N008 QNPN_100
R1 N008 N009 1k
R2 N007 N009 50k
Q5 N002 0 N010 QNPN_100
Q6 N011 N004 N010 QPNP_100
Q7 N011 N007 N012 QNPN_100
R3 N012 N009 1k
V1 N009 0 -15
Q8 N002 N002 N006 QPNP_100
Q9 N004 N002 N006 QPNP_100
V2 N006 0 15
Q10 N004 N013 N014 QNPN_100
Q11 N013 N013 N009 QNPN_100
R4 N014 N009 5k
R5 N013 N015 39k
Q12 N015 N015 N006 QPNP_100
Q13 N016 N015 N006 QPNP_100
Q14 N006 N016 N017 QNPN_100
Q15 N016 N017 N018 QNPN_100
R6 N017 N018 25
R7 N018 N019 50
Q16 N016 N020 N021 QNPN_100
R8 N020 N016 4.5k
R9 N020 N021 7.5k
Q17 N009 N021 N019 QPNP_100
Q18 N021 N022 N023 QNPN_100
Q19 N011 N023 N009 QNPN_100
R10 N023 N009 50
R11 N022 N009 50k
Q20 N021 N011 N022 QNPN_100
C1 N016 N011 30p IC=29.98210972
V3 N001 0 SIN(0 100m 120 0 0 0)
.model QNPN_100 NPN(BF=100 BR=1 IS=1e-13 Cje=1p Cjc=1p)
.model QPNP_100 PNP(BF=100 BR=1 IS=1e-13 Cje=1p Cjc=1p)
.tran 5u 768m 0 5u uic
.end
