* mux
* Converted from CircuitJS by eetree.cn/tools - open in LTspice (File > Open, then Run)
* Suggested traces: V(N003)
M1 N003 N001 N002 0 MN_1p5_20m
D1 N002 N003 D_body
M2 N002 N004 N003 N005 MP_1p5_20m
D2 N002 N003 D_body
V1 N002 0 SIN(2.5 2.5 80 0 0 0)
V2 N006 0 SIN(2.5 2.5 40 0 0 0)
R1 N003 0 1k
* logic gate (output 5 V, threshold 2.5 V, ~1 ns delay)
B1 B1x 0 V=5*(1-u(V(N004)-2.5))
RB1 B1x B1y 1k
CB1 B1y 0 1p IC=0
B1o N001 0 V=V(B1y)
* logic input H
V3 N004 0 5
V4 N005 0 5
V5 N007 0 5
M3 N006 N001 N003 N007 MP_1p5_20m
D3 N006 N003 D_body
M4 N003 N004 N006 0 MN_1p5_20m
D4 N006 N003 D_body
.model D_body D(Is=1.7143528192808883e-7 N=2 Rs=1m Cjo=1p)
.model MN_1p5_20m NMOS(Level=1 VTO=1.5 KP=20m)
.model MP_1p5_20m PMOS(Level=1 VTO=-1.5 KP=20m)
.tran 5u 768m 0 5u uic
.end
