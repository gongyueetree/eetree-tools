* opampfeedback
* Converted from CircuitJS by eetree.cn/tools - open in LTspice (File > Open, then Run)
* op-amp 1: A0=100000, GBW=1000000, output limited to [-15.0, 15.0]
G_OA1 0 OA1 N002 N001 1
R_OA1 OA1 0 100k
C_OA1 OA1 0 159.1549431n
B_OA1 N001 0 V=min(max(V(OA1), -15), 15)
V1 N002 0 3.3
.tran 5u 768m 0 5u uic
.end
