* tlmatch1
* Converted from CircuitJS by eetree.cn/tools - open in LTspice (File > Open, then Run)
* Suggested traces: V(N004) V(N009)
T1 N001 0 N002 0 Z0=75 Td=20n
T2 N003 0 N004 0 Z0=300 Td=20n
R1 N001 N005 75
R2 N004 0 300
V1 N005 0 SIN(0 5 90meg 0 0 0)
L1 N002 N003 250n IC=-9.329316142m
C1 N003 0 10.6p IC=-4.843602086
V2 0 N006 SIN(0 5 90meg 0 0 0)
R3 N006 N007 75
T3 N007 0 N008 0 Z0=75 Td=20n
T4 N008 0 N009 0 Z0=300 Td=20n
R4 N009 0 300
.tran 76.8p 1.536u 0 76.8p uic
.end
