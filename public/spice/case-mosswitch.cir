* mosswitch
* Converted from CircuitJS by eetree.cn/tools - open in LTspice (File > Open, then Run)
* switch open
R1 N001 N002 1e12
R2 N001 N003 300
M1 N003 N002 0 0 MN_1p5_20m
V1 N001 0 5
.model MN_1p5_20m NMOS(Level=1 VTO=1.5 KP=20m)
.tran 5u 768m 0 5u uic
.end
