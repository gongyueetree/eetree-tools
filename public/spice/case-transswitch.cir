* transswitch
* Converted from CircuitJS by eetree.cn/tools - open in LTspice (File > Open, then Run)
V1 N001 0 5
Q1 N003 N002 0 QNPN_100
R1 N001 N004 10k
* switch open
R2 N004 N002 1e12
R3 N001 N003 300
.model QNPN_100 NPN(BF=100 BR=1 IS=1e-13 Cje=1p Cjc=1p)
.tran 5u 768m 0 5u uic
.end
