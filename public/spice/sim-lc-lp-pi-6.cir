# eetree-sim 1
# name lc-lp-pi-6
# param RS 50
# param RL 50
# param fc 1000000
# param SCOPE_W 512
# param C1 1.6476932157756155e-09
# param L1 1.1253953951963825e-05
# param C2 6.149274796561146e-09
# param L2 1.5373186991402865e-05
# param C3 4.501581580785531e-09
# param L3 4.119233039439043e-06
# let fmin = fc/10
# let fmax = fc*4
# let dt = 1/(fmax*24)
# let tsw = 200/fmin
# let ssp = max(1, round(tsw/dt/SCOPE_W))
# let sp = 300
* lc-lp-pi-6
* Converted from CircuitJS by eetree.cn/tools - open in LTspice (File > Open, then Run)
* Suggested traces: V(OUT)
.param C1=${C1} C2=${C2} C3=${C3} L1=${L1} L2=${L2} L3=${L3} RL=${RL} RS=${RS} fmax=${fmax} fmin=${fmin}
RS N001 N002 {RS}
C1 N002 0 {C1} IC=0
L1 N002 N003 {L1} IC=0
C2 N003 0 {C2} IC=0
L2 N003 N004 {L2} IC=0
C3 N004 0 {C3} IC=0
L3 N004 OUT {L3} IC=0
RL OUT 0 {RL}
V1 N001 0 DC 0 AC 2
.ac dec 100 {fmin} {fmax}
.end
