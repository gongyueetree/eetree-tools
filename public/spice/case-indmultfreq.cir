* indmultfreq
* Converted from CircuitJS by eetree.cn/tools - open in LTspice (File > Open, then Run)
* Suggested traces: I(L1) I(L2) I(L3)
V1 N001 0 SIN(0 5 30 0 0 0)
R1 N001 N002 200
V2 N004 N003 SIN(0 5 80 0 0 0)
R2 N004 N005 200
V3 N007 N006 SIN(0 5 200 0 0 0)
R3 N007 N008 200
L1 N002 0 400m IC=12.66799635m
L2 N005 N003 400m IC=5.30277503m
L3 N008 N006 400m IC=9.241480515m
* floating sub-circuit: reference to ground as in CircuitJS
R4 N004 0 100meg
* floating sub-circuit: reference to ground as in CircuitJS
R5 N007 0 100meg
.tran 5u 768m 0 5u uic
.end
