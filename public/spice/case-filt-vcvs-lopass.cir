* filt-vcvs-lopass
* Converted from CircuitJS by eetree.cn/tools - open in LTspice (File > Open, then Run)
* Suggested traces: V(N001) V(N004)
R1 N001 N002 10k
R2 N002 N003 10k
R3 N004 N005 5.86k
R4 N005 0 10k
C1 N003 0 159n IC=5.267839807m
* op-amp 1: A0=100000, GBW=1000000, output limited to [-15.0, 15.0]
G_OA1 0 OA1 N003 N005 1
R_OA1 OA1 0 100k
C_OA1 OA1 0 159.1549431n
B_OA1 N004 0 V=min(max(V(OA1), -15), 15)
C2 N004 N002 159n IC=3.118399354
V1 N001 0 DC 0 AC 5
.ac dec 100 20 800
.end
