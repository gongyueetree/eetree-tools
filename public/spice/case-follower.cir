* follower
* Converted from CircuitJS by eetree.cn/tools - open in LTspice (File > Open, then Run)
* Suggested traces: V(N002) V(N003)
R1 N001 N002 800
R2 N002 0 800
Q1 N001 N002 N003 QNPN_100
R3 N003 0 40
C1 N004 N002 3u IC=1.582355891
V1 N004 0 SIN(0 5 40 0 0 0)
V2 N001 0 5
.model QNPN_100 NPN(BF=100 BR=1 IS=1e-13 Cje=1p Cjc=1p)
.tran 5u 768m 0 5u uic
.end
