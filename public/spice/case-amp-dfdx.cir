* amp-dfdx
* Converted from CircuitJS by eetree.cn/tools - open in LTspice (File > Open, then Run)
* Suggested traces: V(N001) V(N003)
V1 N001 0 PULSE(-5 5 0 12.5m 12.5m 0 25m)
* op-amp 1: A0=1000, GBW=1000000, output limited to [-15, 15]
G_OA1 0 OA1 0 N002 1
R_OA1 OA1 0 1k
C_OA1 OA1 0 159.1549431n
B_OA1 N003 0 V=min(max(V(OA1), -15), 15)
C1 N001 N002 2u IC=165.5984015m
R1 N002 N003 5k
.tran 5u 768m 0 5u uic
.end
