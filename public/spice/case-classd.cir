* classd
* Converted from CircuitJS by eetree.cn/tools - open in LTspice (File > Open, then Run)
* Suggested traces: V(N001) V(N003) V(N007)
* op-amp 1: A0=100000, GBW=1000000, output limited to [-15, 15]
G_OA1 0 OA1 N002 N001 1
R_OA1 OA1 0 100k
C_OA1 OA1 0 159.1549431n
B_OA1 N003 0 V=min(max(V(OA1), -15), 15)
M1 N004 N003 N005 N005 MP_1p5_20m
D1 N004 N005 D_body
M2 N006 N003 N005 N005 MN_1p5_20m
D2 N005 N006 D_body
V1 N006 0 15
L1 N005 N007 80m IC=50.80079809m
C1 N007 0 10u IC=3.12028323
V2 N002 0 PULSE(-1.001 1.001 0 500u 500u 0 1m)
V3 N001 0 SIN(0 1.001 30 0 0 0)
V4 N004 0 -15
.model D_body D(Is=1.7143528192808883e-7 N=2 Rs=1m Cjo=1p)
.model MN_1p5_20m NMOS(Level=1 VTO=1.5 KP=20m)
.model MP_1p5_20m PMOS(Level=1 VTO=-1.5 KP=20m)
.tran 5u 768m 0 5u uic
.end
