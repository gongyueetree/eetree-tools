# eetree-sim 1
# name twin-t
# param R1 3300
# param R2 3300
# param R3 1650
# param C1 4.7e-08
# param C2 4.7e-08
# param C3 9.4e-08
# param SCOPE_W 512
# let fc = 1/(2*PI*R1*C1)
# let fmin = fc/10
# let fmax = fc*10
# let dt = 1/(fmax*24)
# let tsw = 60/fmin
# let ssp = max(1, round(tsw/dt/SCOPE_W))
# let sp = 300
* twin-t
* Converted from CircuitJS by eetree.cn/tools - open in LTspice (File > Open, then Run)
* Suggested traces: V(OUT)
.param C1=${C1} C2=${C2} C3=${C3} R1=${R1} R2=${R2} R3=${R3} fmax=${fmax} fmin=${fmin}
R1 N001 N002 {R1}
R2 N002 OUT {R2}
C1 N001 N003 {C1} IC=0
C2 N003 OUT {C2} IC=0
C3 N002 0 {C3} IC=0
R3 N003 0 {R3}
V1 N001 0 DC 0 AC 1
.ac dec 100 {fmin} {fmax}
.end
