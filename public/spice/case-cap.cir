* cap
* Converted from CircuitJS by eetree.cn/tools - open in LTspice (File > Open, then Run)
* Suggested traces: V(N002,N003)
V1 N001 0 5
* SPDT switch throw 0 on
R1 N002 N001 1m
* SPDT switch throw 1 off
R2 N002 0 1e12
C1 N002 N003 200u IC=0
R3 N003 0 100
.tran 7.68u 1.536 0 7.68u uic
.end
