* rtlnor
* Converted from CircuitJS by eetree.cn/tools - open in LTspice (File > Open, then Run)
Q1 N002 N001 0 QNPN_100
Q2 N002 N003 0 QNPN_100
Q3 N002 N004 0 QNPN_100
R1 N001 N005 470
R2 N003 N006 470
R3 N004 N007 470
* logic input H
V1 N005 0 3.6
* logic input L
V2 N006 0 0
* logic input L
V3 N007 0 0
R4 N002 N008 640
V4 N008 0 3.6
.model QNPN_100 NPN(BF=100 BR=1 IS=1e-13 Cje=1p Cjc=1p)
.tran 5u 768m 0 5u uic
.end
