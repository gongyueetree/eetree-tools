* cmosinvertercap
* Converted from CircuitJS by eetree.cn/tools - open in LTspice (File > Open, then Run)
M1 N002 N001 N003 N003 MP_1p5_20m
M2 N002 N001 0 0 MN_1p5_20m
C1 N004 N003 10p IC=-5
C2 N002 N001 10p IC=4.999999286
C3 0 N005 10p IC=1.627940559e-23
V1 N003 0 5
* logic input L
V2 N001 0 0
R1 N004 N001 5
R2 N001 N005 5
.model MN_1p5_20m NMOS(Level=1 VTO=1.5 KP=20m)
.model MP_1p5_20m PMOS(Level=1 VTO=-1.5 KP=20m)
.tran 1p 153.6n 0 1p uic
.end
